* NGSPICE file created from UART.ext - technology: sky130A

* Black-box entry subcircuit for sky130_fd_sc_hd__tapvpwrvgnd_1 abstract view
.subckt sky130_fd_sc_hd__tapvpwrvgnd_1 VGND VPWR
.ends

* Black-box entry subcircuit for sky130_fd_sc_hd__fill_2 abstract view
.subckt sky130_fd_sc_hd__fill_2 VGND VNB VPB VPWR
.ends

* Black-box entry subcircuit for sky130_fd_sc_hd__or2b_1 abstract view
.subckt sky130_fd_sc_hd__or2b_1 A B_N VGND VNB VPB VPWR X
.ends

* Black-box entry subcircuit for sky130_fd_sc_hd__nand2_1 abstract view
.subckt sky130_fd_sc_hd__nand2_1 A B VGND VNB VPB VPWR Y
.ends

* Black-box entry subcircuit for sky130_fd_sc_hd__clkbuf_1 abstract view
.subckt sky130_fd_sc_hd__clkbuf_1 A VGND VNB VPB VPWR X
.ends

* Black-box entry subcircuit for sky130_fd_sc_hd__mux2_1 abstract view
.subckt sky130_fd_sc_hd__mux2_1 A0 A1 S VGND VNB VPB VPWR X
.ends

* Black-box entry subcircuit for sky130_fd_sc_hd__or4_1 abstract view
.subckt sky130_fd_sc_hd__or4_1 A B C D VGND VNB VPB VPWR X
.ends

* Black-box entry subcircuit for sky130_fd_sc_hd__xnor2_1 abstract view
.subckt sky130_fd_sc_hd__xnor2_1 A B VGND VNB VPB VPWR Y
.ends

* Black-box entry subcircuit for sky130_fd_sc_hd__decap_4 abstract view
.subckt sky130_fd_sc_hd__decap_4 VGND VNB VPB VPWR
.ends

* Black-box entry subcircuit for sky130_fd_sc_hd__decap_3 abstract view
.subckt sky130_fd_sc_hd__decap_3 VGND VNB VPB VPWR
.ends

* Black-box entry subcircuit for sky130_fd_sc_hd__a211o_1 abstract view
.subckt sky130_fd_sc_hd__a211o_1 A1 A2 B1 C1 VGND VNB VPB VPWR X
.ends

* Black-box entry subcircuit for sky130_fd_sc_hd__fill_1 abstract view
.subckt sky130_fd_sc_hd__fill_1 VGND VNB VPB VPWR
.ends

* Black-box entry subcircuit for sky130_fd_sc_hd__o311a_1 abstract view
.subckt sky130_fd_sc_hd__o311a_1 A1 A2 A3 B1 C1 VGND VNB VPB VPWR X
.ends

* Black-box entry subcircuit for sky130_fd_sc_hd__dlygate4sd3_1 abstract view
.subckt sky130_fd_sc_hd__dlygate4sd3_1 A VGND VNB VPB VPWR X
.ends

* Black-box entry subcircuit for sky130_ef_sc_hd__decap_12 abstract view
.subckt sky130_ef_sc_hd__decap_12 VPWR VGND VPB VNB
.ends

* Black-box entry subcircuit for sky130_fd_sc_hd__dfrtp_1 abstract view
.subckt sky130_fd_sc_hd__dfrtp_1 CLK D RESET_B VGND VNB VPB VPWR Q
.ends

* Black-box entry subcircuit for sky130_fd_sc_hd__diode_2 abstract view
.subckt sky130_fd_sc_hd__diode_2 DIODE VGND VNB VPB VPWR
.ends

* Black-box entry subcircuit for sky130_fd_sc_hd__clkbuf_4 abstract view
.subckt sky130_fd_sc_hd__clkbuf_4 A VGND VNB VPB VPWR X
.ends

* Black-box entry subcircuit for sky130_fd_sc_hd__a21oi_1 abstract view
.subckt sky130_fd_sc_hd__a21oi_1 A1 A2 B1 VGND VNB VPB VPWR Y
.ends

* Black-box entry subcircuit for sky130_fd_sc_hd__clkbuf_16 abstract view
.subckt sky130_fd_sc_hd__clkbuf_16 A VGND VNB VPB VPWR X
.ends

* Black-box entry subcircuit for sky130_fd_sc_hd__and3_1 abstract view
.subckt sky130_fd_sc_hd__and3_1 A B C VGND VNB VPB VPWR X
.ends

* Black-box entry subcircuit for sky130_fd_sc_hd__or4_2 abstract view
.subckt sky130_fd_sc_hd__or4_2 A B C D VGND VNB VPB VPWR X
.ends

* Black-box entry subcircuit for sky130_fd_sc_hd__nor3_1 abstract view
.subckt sky130_fd_sc_hd__nor3_1 A B C VGND VNB VPB VPWR Y
.ends

* Black-box entry subcircuit for sky130_fd_sc_hd__nor3b_1 abstract view
.subckt sky130_fd_sc_hd__nor3b_1 A B C_N VGND VNB VPB VPWR Y
.ends

* Black-box entry subcircuit for sky130_fd_sc_hd__nand3_1 abstract view
.subckt sky130_fd_sc_hd__nand3_1 A B C VGND VNB VPB VPWR Y
.ends

* Black-box entry subcircuit for sky130_fd_sc_hd__dfrtp_2 abstract view
.subckt sky130_fd_sc_hd__dfrtp_2 CLK D RESET_B VGND VNB VPB VPWR Q
.ends

* Black-box entry subcircuit for sky130_fd_sc_hd__decap_6 abstract view
.subckt sky130_fd_sc_hd__decap_6 VGND VNB VPB VPWR
.ends

* Black-box entry subcircuit for sky130_fd_sc_hd__o21ai_1 abstract view
.subckt sky130_fd_sc_hd__o21ai_1 A1 A2 B1 VGND VNB VPB VPWR Y
.ends

* Black-box entry subcircuit for sky130_fd_sc_hd__nor2_1 abstract view
.subckt sky130_fd_sc_hd__nor2_1 A B VGND VNB VPB VPWR Y
.ends

* Black-box entry subcircuit for sky130_fd_sc_hd__a21bo_1 abstract view
.subckt sky130_fd_sc_hd__a21bo_1 A1 A2 B1_N VGND VNB VPB VPWR X
.ends

* Black-box entry subcircuit for sky130_fd_sc_hd__o32a_1 abstract view
.subckt sky130_fd_sc_hd__o32a_1 A1 A2 A3 B1 B2 VGND VNB VPB VPWR X
.ends

* Black-box entry subcircuit for sky130_fd_sc_hd__clkbuf_2 abstract view
.subckt sky130_fd_sc_hd__clkbuf_2 A VGND VNB VPB VPWR X
.ends

* Black-box entry subcircuit for sky130_fd_sc_hd__decap_8 abstract view
.subckt sky130_fd_sc_hd__decap_8 VGND VNB VPB VPWR
.ends

* Black-box entry subcircuit for sky130_fd_sc_hd__and2_1 abstract view
.subckt sky130_fd_sc_hd__and2_1 A B VGND VNB VPB VPWR X
.ends

* Black-box entry subcircuit for sky130_fd_sc_hd__inv_2 abstract view
.subckt sky130_fd_sc_hd__inv_2 A VGND VNB VPB VPWR Y
.ends

* Black-box entry subcircuit for sky130_fd_sc_hd__or3b_1 abstract view
.subckt sky130_fd_sc_hd__or3b_1 A B C_N VGND VNB VPB VPWR X
.ends

* Black-box entry subcircuit for sky130_fd_sc_hd__a21o_1 abstract view
.subckt sky130_fd_sc_hd__a21o_1 A1 A2 B1 VGND VNB VPB VPWR X
.ends

* Black-box entry subcircuit for sky130_fd_sc_hd__buf_2 abstract view
.subckt sky130_fd_sc_hd__buf_2 A VGND VNB VPB VPWR X
.ends

* Black-box entry subcircuit for sky130_fd_sc_hd__clkinv_2 abstract view
.subckt sky130_fd_sc_hd__clkinv_2 A VGND VNB VPB VPWR Y
.ends

* Black-box entry subcircuit for sky130_fd_sc_hd__and2b_1 abstract view
.subckt sky130_fd_sc_hd__and2b_1 A_N B VGND VNB VPB VPWR X
.ends

* Black-box entry subcircuit for sky130_fd_sc_hd__a22o_1 abstract view
.subckt sky130_fd_sc_hd__a22o_1 A1 A2 B1 B2 VGND VNB VPB VPWR X
.ends

* Black-box entry subcircuit for sky130_fd_sc_hd__clkinv_4 abstract view
.subckt sky130_fd_sc_hd__clkinv_4 A VGND VNB VPB VPWR Y
.ends

* Black-box entry subcircuit for sky130_fd_sc_hd__a32o_1 abstract view
.subckt sky130_fd_sc_hd__a32o_1 A1 A2 A3 B1 B2 VGND VNB VPB VPWR X
.ends

* Black-box entry subcircuit for sky130_fd_sc_hd__or2_1 abstract view
.subckt sky130_fd_sc_hd__or2_1 A B VGND VNB VPB VPWR X
.ends

* Black-box entry subcircuit for sky130_fd_sc_hd__clkinvlp_4 abstract view
.subckt sky130_fd_sc_hd__clkinvlp_4 A VGND VNB VPB VPWR Y
.ends

* Black-box entry subcircuit for sky130_fd_sc_hd__or4b_2 abstract view
.subckt sky130_fd_sc_hd__or4b_2 A B C D_N VGND VNB VPB VPWR X
.ends

* Black-box entry subcircuit for sky130_fd_sc_hd__o211a_1 abstract view
.subckt sky130_fd_sc_hd__o211a_1 A1 A2 B1 C1 VGND VNB VPB VPWR X
.ends

* Black-box entry subcircuit for sky130_fd_sc_hd__nor3b_2 abstract view
.subckt sky130_fd_sc_hd__nor3b_2 A B C_N VGND VNB VPB VPWR Y
.ends

* Black-box entry subcircuit for sky130_fd_sc_hd__o2bb2a_1 abstract view
.subckt sky130_fd_sc_hd__o2bb2a_1 A1_N A2_N B1 B2 VGND VNB VPB VPWR X
.ends

* Black-box entry subcircuit for sky130_fd_sc_hd__or3_1 abstract view
.subckt sky130_fd_sc_hd__or3_1 A B C VGND VNB VPB VPWR X
.ends

* Black-box entry subcircuit for sky130_fd_sc_hd__o21a_1 abstract view
.subckt sky130_fd_sc_hd__o21a_1 A1 A2 B1 VGND VNB VPB VPWR X
.ends

* Black-box entry subcircuit for sky130_fd_sc_hd__dlymetal6s2s_1 abstract view
.subckt sky130_fd_sc_hd__dlymetal6s2s_1 A VGND VNB VPB VPWR X
.ends

* Black-box entry subcircuit for sky130_fd_sc_hd__a31o_1 abstract view
.subckt sky130_fd_sc_hd__a31o_1 A1 A2 A3 B1 VGND VNB VPB VPWR X
.ends

* Black-box entry subcircuit for sky130_fd_sc_hd__and4_1 abstract view
.subckt sky130_fd_sc_hd__and4_1 A B C D VGND VNB VPB VPWR X
.ends

* Black-box entry subcircuit for sky130_fd_sc_hd__buf_1 abstract view
.subckt sky130_fd_sc_hd__buf_1 A VGND VNB VPB VPWR X
.ends

* Black-box entry subcircuit for sky130_fd_sc_hd__nor2_2 abstract view
.subckt sky130_fd_sc_hd__nor2_2 A B VGND VNB VPB VPWR Y
.ends

* Black-box entry subcircuit for sky130_fd_sc_hd__xor2_1 abstract view
.subckt sky130_fd_sc_hd__xor2_1 A B VGND VNB VPB VPWR X
.ends

* Black-box entry subcircuit for sky130_fd_sc_hd__a2111oi_1 abstract view
.subckt sky130_fd_sc_hd__a2111oi_1 A1 A2 B1 C1 D1 VGND VNB VPB VPWR Y
.ends

* Black-box entry subcircuit for sky130_fd_sc_hd__nor4_1 abstract view
.subckt sky130_fd_sc_hd__nor4_1 A B C D VGND VNB VPB VPWR Y
.ends

* Black-box entry subcircuit for sky130_fd_sc_hd__dfstp_1 abstract view
.subckt sky130_fd_sc_hd__dfstp_1 CLK D SET_B VGND VNB VPB VPWR Q
.ends

* Black-box entry subcircuit for sky130_fd_sc_hd__and4bb_2 abstract view
.subckt sky130_fd_sc_hd__and4bb_2 A_N B_N C D VGND VNB VPB VPWR X
.ends

* Black-box entry subcircuit for sky130_fd_sc_hd__or4b_1 abstract view
.subckt sky130_fd_sc_hd__or4b_1 A B C D_N VGND VNB VPB VPWR X
.ends

* Black-box entry subcircuit for sky130_fd_sc_hd__a221o_1 abstract view
.subckt sky130_fd_sc_hd__a221o_1 A1 A2 B1 B2 C1 VGND VNB VPB VPWR X
.ends

* Black-box entry subcircuit for sky130_fd_sc_hd__o21ba_1 abstract view
.subckt sky130_fd_sc_hd__o21ba_1 A1 A2 B1_N VGND VNB VPB VPWR X
.ends

* Black-box entry subcircuit for sky130_fd_sc_hd__nor2b_2 abstract view
.subckt sky130_fd_sc_hd__nor2b_2 A B_N VGND VNB VPB VPWR Y
.ends

* Black-box entry subcircuit for sky130_fd_sc_hd__and4b_1 abstract view
.subckt sky130_fd_sc_hd__and4b_1 A_N B C D VGND VNB VPB VPWR X
.ends

* Black-box entry subcircuit for sky130_fd_sc_hd__o22ai_1 abstract view
.subckt sky130_fd_sc_hd__o22ai_1 A1 A2 B1 B2 VGND VNB VPB VPWR Y
.ends

* Black-box entry subcircuit for sky130_fd_sc_hd__a2111o_1 abstract view
.subckt sky130_fd_sc_hd__a2111o_1 A1 A2 B1 C1 D1 VGND VNB VPB VPWR X
.ends

* Black-box entry subcircuit for sky130_fd_sc_hd__a211oi_1 abstract view
.subckt sky130_fd_sc_hd__a211oi_1 A1 A2 B1 C1 VGND VNB VPB VPWR Y
.ends

* Black-box entry subcircuit for sky130_fd_sc_hd__a311o_1 abstract view
.subckt sky130_fd_sc_hd__a311o_1 A1 A2 A3 B1 C1 VGND VNB VPB VPWR X
.ends

* Black-box entry subcircuit for sky130_fd_sc_hd__o221a_1 abstract view
.subckt sky130_fd_sc_hd__o221a_1 A1 A2 B1 B2 C1 VGND VNB VPB VPWR X
.ends

.subckt UART VGND VPWR clk div[0] div[10] div[11] div[1] div[2] div[3] div[4] div[5]
+ div[6] div[7] div[8] div[9] framingError parityEnable parityError parityErrorValid
+ parityType rst rx rx_busy rx_done rx_out[0] rx_out[1] rx_out[2] rx_out[3] rx_out[4]
+ rx_out[5] rx_out[6] rx_out[7] tx tx_busy tx_data_valid tx_done tx_in[0] tx_in[1]
+ tx_in[2] tx_in[3] tx_in[4] tx_in[5] tx_in[6] tx_in[7]
XTAP_TAPCELL_ROW_32_183 VGND VPWR sky130_fd_sc_hd__tapvpwrvgnd_1
XFILLER_0_17_200 VGND VGND VPWR VPWR sky130_fd_sc_hd__fill_2
XFILLER_0_4_171 VGND VGND VPWR VPWR sky130_fd_sc_hd__fill_2
XTAP_TAPCELL_ROW_9_104 VGND VPWR sky130_fd_sc_hd__tapvpwrvgnd_1
X_363_ BRG.counter\[0\] net1 VGND VGND VPWR VPWR _143_ sky130_fd_sc_hd__or2b_1
X_294_ _076_ _070_ VGND VGND VPWR VPWR _084_ sky130_fd_sc_hd__nand2_1
X_432_ _197_ VGND VGND VPWR VPWR _012_ sky130_fd_sc_hd__clkbuf_1
X_501_ txtop.serializer.memory\[4\] net21 net17 VGND VGND VPWR VPWR _244_ sky130_fd_sc_hd__mux2_1
X_346_ net7 net8 net9 net10 VGND VGND VPWR VPWR _126_ sky130_fd_sc_hd__or4_1
X_415_ BRG.counter\[10\] _183_ VGND VGND VPWR VPWR _185_ sky130_fd_sc_hd__xnor2_1
XTAP_TAPCELL_ROW_20_142 VGND VPWR sky130_fd_sc_hd__tapvpwrvgnd_1
XFILLER_0_18_29 VGND VGND VPWR VPWR sky130_fd_sc_hd__decap_4
XPHY_EDGE_ROW_0_Left_34 VGND VGND VPWR VPWR sky130_fd_sc_hd__decap_3
XTAP_TAPCELL_ROW_8_99 VGND VPWR sky130_fd_sc_hd__tapvpwrvgnd_1
X_277_ _067_ _068_ _064_ net42 VGND VGND VPWR VPWR net29 sky130_fd_sc_hd__a211o_1
XFILLER_0_6_200 VGND VGND VPWR VPWR sky130_fd_sc_hd__fill_2
XFILLER_0_28_125 VGND VGND VPWR VPWR sky130_fd_sc_hd__fill_1
X_329_ _093_ _095_ _100_ _110_ _111_ VGND VGND VPWR VPWR rxtop.fsm_rx.BAUD_COUNTER_Next\[3\]
+ sky130_fd_sc_hd__o311a_1
XFILLER_0_10_96 VGND VGND VPWR VPWR sky130_fd_sc_hd__fill_2
XFILLER_0_10_85 VGND VGND VPWR VPWR sky130_fd_sc_hd__fill_2
XFILLER_0_0_29 VGND VGND VPWR VPWR sky130_fd_sc_hd__fill_2
XFILLER_0_27_191 VGND VGND VPWR VPWR sky130_fd_sc_hd__decap_3
XFILLER_0_19_72 VGND VGND VPWR VPWR sky130_fd_sc_hd__fill_2
XFILLER_0_25_117 VGND VGND VPWR VPWR sky130_fd_sc_hd__fill_1
XTAP_TAPCELL_ROW_5_89 VGND VPWR sky130_fd_sc_hd__tapvpwrvgnd_1
XFILLER_0_30_197 VGND VGND VPWR VPWR sky130_fd_sc_hd__decap_4
XFILLER_0_30_153 VGND VGND VPWR VPWR sky130_fd_sc_hd__decap_4
Xhold63 BRG.counter\[11\] VGND VGND VPWR VPWR net119 sky130_fd_sc_hd__dlygate4sd3_1
XFILLER_0_26_29 VPWR VGND VPWR VGND sky130_ef_sc_hd__decap_12
Xhold30 rxtop.pCheck.memory\[3\] VGND VGND VPWR VPWR net86 sky130_fd_sc_hd__dlygate4sd3_1
Xhold41 net35 VGND VGND VPWR VPWR net97 sky130_fd_sc_hd__dlygate4sd3_1
Xhold52 txtop.fsm_tx.BAUD_COUNTER\[0\] VGND VGND VPWR VPWR net108 sky130_fd_sc_hd__dlygate4sd3_1
X_594_ clknet_3_0__leaf_clk net62 net45 VGND VGND VPWR VPWR txtop.serializer.memory\[5\]
+ sky130_fd_sc_hd__dfrtp_1
XANTENNA_input18_A tx_in[0] VGND VGND VPWR VPWR sky130_fd_sc_hd__diode_2
XFILLER_0_32_83 VGND VGND VPWR VPWR sky130_fd_sc_hd__fill_1
XFILLER_0_16_95 VGND VGND VPWR VPWR sky130_fd_sc_hd__fill_2
Xoutput31 net31 VGND VGND VPWR VPWR rx_out[0] sky130_fd_sc_hd__clkbuf_4
XFILLER_0_26_201 VGND VGND VPWR VPWR sky130_fd_sc_hd__fill_1
X_577_ clknet_3_6__leaf_clk _007_ net48 VGND VGND VPWR VPWR BRG.counter\[5\] sky130_fd_sc_hd__dfrtp_1
XTAP_TAPCELL_ROW_18_137 VGND VPWR sky130_fd_sc_hd__tapvpwrvgnd_1
XTAP_TAPCELL_ROW_2_79 VGND VPWR sky130_fd_sc_hd__tapvpwrvgnd_1
XTAP_TAPCELL_ROW_32_184 VGND VPWR sky130_fd_sc_hd__tapvpwrvgnd_1
XFILLER_0_7_82 VGND VGND VPWR VPWR sky130_fd_sc_hd__decap_3
XTAP_TAPCELL_ROW_9_105 VGND VPWR sky130_fd_sc_hd__tapvpwrvgnd_1
X_362_ _138_ _141_ BRG.counter\[2\] VGND VGND VPWR VPWR _142_ sky130_fd_sc_hd__a21oi_1
Xclkbuf_3_6__f_clk clknet_0_clk VGND VGND VPWR VPWR clknet_3_6__leaf_clk sky130_fd_sc_hd__clkbuf_16
X_293_ txtop.fsm_tx.BAUD_COUNTER\[1\] txtop.fsm_tx.BAUD_COUNTER\[0\] _075_ VGND VGND
+ VPWR VPWR _083_ sky130_fd_sc_hd__and3_1
X_500_ _243_ VGND VGND VPWR VPWR _034_ sky130_fd_sc_hd__clkbuf_1
X_431_ _191_ _068_ _196_ VGND VGND VPWR VPWR _197_ sky130_fd_sc_hd__mux2_1
XTAP_TAPCELL_ROW_20_143 VGND VPWR sky130_fd_sc_hd__tapvpwrvgnd_1
X_345_ net1 net4 net5 net6 VGND VGND VPWR VPWR _125_ sky130_fd_sc_hd__or4_2
X_414_ _167_ _183_ _184_ VGND VGND VPWR VPWR _011_ sky130_fd_sc_hd__nor3_1
XFILLER_0_24_40 VGND VGND VPWR VPWR sky130_fd_sc_hd__fill_2
XTAP_TAPCELL_ROW_11_110 VGND VPWR sky130_fd_sc_hd__tapvpwrvgnd_1
X_276_ _066_ _068_ rxtop.fsm_rx.Current\[1\] VGND VGND VPWR VPWR _069_ sky130_fd_sc_hd__nor3b_1
XPHY_EDGE_ROW_21_Right_21 VGND VGND VPWR VPWR sky130_fd_sc_hd__decap_3
XPHY_EDGE_ROW_12_Right_12 VGND VGND VPWR VPWR sky130_fd_sc_hd__decap_3
XFILLER_0_4_83 VGND VGND VPWR VPWR sky130_fd_sc_hd__fill_1
XPHY_EDGE_ROW_30_Right_30 VGND VGND VPWR VPWR sky130_fd_sc_hd__decap_3
X_328_ rxtop.fsm_rx.BAUD_COUNTER\[2\] rxtop.fsm_rx.BAUD_COUNTER\[3\] _104_ VGND VGND
+ VPWR VPWR _111_ sky130_fd_sc_hd__nand3_1
XFILLER_0_31_19 VGND VGND VPWR VPWR sky130_fd_sc_hd__decap_4
XFILLER_0_24_195 VGND VGND VPWR VPWR sky130_fd_sc_hd__fill_1
XFILLER_0_30_132 VGND VGND VPWR VPWR sky130_fd_sc_hd__fill_2
Xhold31 _052_ VGND VGND VPWR VPWR net87 sky130_fd_sc_hd__dlygate4sd3_1
Xhold20 _053_ VGND VGND VPWR VPWR net76 sky130_fd_sc_hd__dlygate4sd3_1
Xhold42 net36 VGND VGND VPWR VPWR net98 sky130_fd_sc_hd__dlygate4sd3_1
Xhold53 txtop.fsm_tx.BAUD_COUNTER_Next\[0\] VGND VGND VPWR VPWR net109 sky130_fd_sc_hd__dlygate4sd3_1
Xhold64 txtop.serializer.ptr\[2\] VGND VGND VPWR VPWR net120 sky130_fd_sc_hd__dlygate4sd3_1
XFILLER_0_21_110 VGND VGND VPWR VPWR sky130_fd_sc_hd__fill_2
XFILLER_0_16_63 VPWR VGND VPWR VGND sky130_ef_sc_hd__decap_12
X_593_ clknet_3_0__leaf_clk net67 net45 VGND VGND VPWR VPWR txtop.serializer.memory\[4\]
+ sky130_fd_sc_hd__dfrtp_1
XFILLER_0_6_29 VGND VGND VPWR VPWR sky130_fd_sc_hd__decap_3
XFILLER_0_12_121 VPWR VGND VPWR VGND sky130_ef_sc_hd__decap_12
XPHY_EDGE_ROW_6_Right_6 VGND VGND VPWR VPWR sky130_fd_sc_hd__decap_3
XFILLER_0_8_137 VGND VGND VPWR VPWR sky130_fd_sc_hd__decap_3
Xoutput32 net32 VGND VGND VPWR VPWR rx_out[1] sky130_fd_sc_hd__clkbuf_4
X_576_ clknet_3_3__leaf_clk _006_ net48 VGND VGND VPWR VPWR BRG.counter\[4\] sky130_fd_sc_hd__dfrtp_2
XFILLER_0_7_192 VGND VGND VPWR VPWR sky130_fd_sc_hd__decap_6
XTAP_TAPCELL_ROW_32_185 VGND VPWR sky130_fd_sc_hd__tapvpwrvgnd_1
X_361_ net1 net4 net5 VGND VGND VPWR VPWR _141_ sky130_fd_sc_hd__o21ai_1
XTAP_TAPCELL_ROW_23_152 VGND VPWR sky130_fd_sc_hd__tapvpwrvgnd_1
X_292_ _081_ _082_ VGND VGND VPWR VPWR txtop.fsm_tx.BAUD_COUNTER_Next\[0\] sky130_fd_sc_hd__nor2_1
XFILLER_0_4_195 VGND VGND VPWR VPWR sky130_fd_sc_hd__fill_1
XFILLER_0_7_50 VGND VGND VPWR VPWR sky130_fd_sc_hd__fill_2
X_430_ rx_synchronizer.rx_out _190_ _195_ VGND VGND VPWR VPWR _196_ sky130_fd_sc_hd__a21bo_1
X_559_ clknet_3_6__leaf_clk _021_ net53 VGND VGND VPWR VPWR net35 sky130_fd_sc_hd__dfrtp_1
XFILLER_0_1_110 VGND VGND VPWR VPWR sky130_fd_sc_hd__fill_2
XTAP_TAPCELL_ROW_20_144 VGND VPWR sky130_fd_sc_hd__tapvpwrvgnd_1
X_413_ BRG.counter\[9\] _181_ VGND VGND VPWR VPWR _184_ sky130_fd_sc_hd__nor2_1
XTAP_TAPCELL_ROW_11_111 VGND VPWR sky130_fd_sc_hd__tapvpwrvgnd_1
X_344_ txtop.fsm_tx.Current\[2\] _114_ _123_ _124_ txtop.data_mux_wire VGND VGND VPWR
+ VPWR net39 sky130_fd_sc_hd__o32a_1
X_275_ rxtop.fsm_rx.Current\[0\] VGND VGND VPWR VPWR _068_ sky130_fd_sc_hd__clkbuf_2
XFILLER_0_24_96 VGND VGND VPWR VPWR sky130_fd_sc_hd__fill_2
XFILLER_0_28_149 VGND VGND VPWR VPWR sky130_fd_sc_hd__decap_3
X_327_ _097_ _108_ VGND VGND VPWR VPWR _110_ sky130_fd_sc_hd__nand2_1
XFILLER_0_9_29 VGND VGND VPWR VPWR sky130_fd_sc_hd__decap_3
XFILLER_0_33_163 VGND VGND VPWR VPWR sky130_fd_sc_hd__decap_4
XFILLER_0_33_141 VGND VGND VPWR VPWR sky130_fd_sc_hd__fill_2
Xhold43 net32 VGND VGND VPWR VPWR net99 sky130_fd_sc_hd__dlygate4sd3_1
Xhold32 net34 VGND VGND VPWR VPWR net88 sky130_fd_sc_hd__dlygate4sd3_1
XFILLER_0_21_177 VGND VGND VPWR VPWR sky130_fd_sc_hd__decap_4
XFILLER_0_21_166 VGND VGND VPWR VPWR sky130_fd_sc_hd__fill_2
Xhold21 rxtop.pCheck.memory\[6\] VGND VGND VPWR VPWR net77 sky130_fd_sc_hd__dlygate4sd3_1
Xhold10 txtop.serializer.memory\[5\] VGND VGND VPWR VPWR net66 sky130_fd_sc_hd__dlygate4sd3_1
Xhold65 txtop.serializer.ptr\[2\] VGND VGND VPWR VPWR net121 sky130_fd_sc_hd__dlygate4sd3_1
X_592_ clknet_3_0__leaf_clk _035_ net45 VGND VGND VPWR VPWR txtop.serializer.memory\[3\]
+ sky130_fd_sc_hd__dfrtp_1
Xhold54 txtop.fsm_tx.Current\[0\] VGND VGND VPWR VPWR net110 sky130_fd_sc_hd__dlygate4sd3_1
XFILLER_0_32_85 VGND VGND VPWR VPWR sky130_fd_sc_hd__decap_4
XFILLER_0_32_41 VPWR VGND VPWR VGND sky130_ef_sc_hd__decap_12
XFILLER_0_29_200 VGND VGND VPWR VPWR sky130_fd_sc_hd__fill_2
XFILLER_0_16_75 VGND VGND VPWR VPWR sky130_fd_sc_hd__decap_8
XFILLER_0_12_177 VGND VGND VPWR VPWR sky130_fd_sc_hd__decap_3
XFILLER_0_12_133 VGND VGND VPWR VPWR sky130_fd_sc_hd__decap_6
Xoutput33 net33 VGND VGND VPWR VPWR rx_out[2] sky130_fd_sc_hd__clkbuf_4
X_575_ clknet_3_6__leaf_clk _005_ net55 VGND VGND VPWR VPWR BRG.counter\[3\] sky130_fd_sc_hd__dfrtp_1
XANTENNA_input23_A tx_in[5] VGND VGND VPWR VPWR sky130_fd_sc_hd__diode_2
XFILLER_0_7_160 VGND VGND VPWR VPWR sky130_fd_sc_hd__decap_4
XANTENNA_clkbuf_3_1__f_clk_A clknet_0_clk VGND VGND VPWR VPWR sky130_fd_sc_hd__diode_2
XTAP_TAPCELL_ROW_32_186 VGND VPWR sky130_fd_sc_hd__tapvpwrvgnd_1
X_360_ BRG.counter\[3\] _139_ VGND VGND VPWR VPWR _140_ sky130_fd_sc_hd__xnor2_1
XTAP_TAPCELL_ROW_23_153 VGND VPWR sky130_fd_sc_hd__tapvpwrvgnd_1
X_291_ txtop.fsm_tx.BAUD_COUNTER\[0\] _075_ VGND VGND VPWR VPWR _082_ sky130_fd_sc_hd__and2_1
XFILLER_0_4_141 VGND VGND VPWR VPWR sky130_fd_sc_hd__decap_4
X_558_ clknet_3_6__leaf_clk _020_ net54 VGND VGND VPWR VPWR net34 sky130_fd_sc_hd__dfrtp_1
XTAP_TAPCELL_ROW_14_120 VGND VPWR sky130_fd_sc_hd__tapvpwrvgnd_1
X_489_ net17 _234_ VGND VGND VPWR VPWR _235_ sky130_fd_sc_hd__nor2_1
XPHY_EDGE_ROW_19_Left_53 VGND VGND VPWR VPWR sky130_fd_sc_hd__decap_3
XFILLER_0_1_155 VPWR VGND VPWR VGND sky130_ef_sc_hd__decap_12
X_412_ BRG.counter\[9\] _181_ VGND VGND VPWR VPWR _183_ sky130_fd_sc_hd__and2_1
XTAP_TAPCELL_ROW_11_112 VGND VPWR sky130_fd_sc_hd__tapvpwrvgnd_1
X_274_ _066_ VGND VGND VPWR VPWR _067_ sky130_fd_sc_hd__inv_2
X_343_ txtop.fsm_tx.Current\[2\] txtop.fsm_tx.Current\[0\] txtop.fsm_tx.Current\[1\]
+ VGND VGND VPWR VPWR _124_ sky130_fd_sc_hd__or3b_1
XFILLER_0_4_41 VPWR VGND VPWR VGND sky130_ef_sc_hd__decap_12
XFILLER_0_4_85 VGND VGND VPWR VPWR sky130_fd_sc_hd__fill_2
XPHY_EDGE_ROW_4_Left_38 VGND VGND VPWR VPWR sky130_fd_sc_hd__decap_3
XFILLER_0_28_139 VGND VGND VPWR VPWR sky130_fd_sc_hd__fill_1
XFILLER_0_28_117 VGND VGND VPWR VPWR sky130_fd_sc_hd__decap_8
XFILLER_0_19_64 VGND VGND VPWR VPWR sky130_fd_sc_hd__decap_8
X_326_ _109_ VGND VGND VPWR VPWR rxtop.fsm_rx.BAUD_COUNTER_Next\[2\] sky130_fd_sc_hd__clkbuf_1
XFILLER_0_10_55 VGND VGND VPWR VPWR sky130_fd_sc_hd__fill_1
XTAP_TAPCELL_ROW_0_70 VGND VPWR sky130_fd_sc_hd__tapvpwrvgnd_1
XFILLER_0_33_197 VGND VGND VPWR VPWR sky130_fd_sc_hd__decap_4
X_309_ rxtop.fsm_rx.Current\[0\] _094_ _064_ VGND VGND VPWR VPWR _095_ sky130_fd_sc_hd__a21o_1
XFILLER_0_24_197 VGND VGND VPWR VPWR sky130_fd_sc_hd__fill_1
XFILLER_0_21_98 VPWR VGND VPWR VGND sky130_ef_sc_hd__decap_12
Xhold44 _018_ VGND VGND VPWR VPWR net100 sky130_fd_sc_hd__dlygate4sd3_1
Xhold33 _019_ VGND VGND VPWR VPWR net89 sky130_fd_sc_hd__dlygate4sd3_1
Xhold22 _055_ VGND VGND VPWR VPWR net78 sky130_fd_sc_hd__dlygate4sd3_1
Xhold11 _036_ VGND VGND VPWR VPWR net67 sky130_fd_sc_hd__dlygate4sd3_1
X_591_ clknet_3_0__leaf_clk _034_ net45 VGND VGND VPWR VPWR txtop.serializer.memory\[2\]
+ sky130_fd_sc_hd__dfrtp_1
XPHY_EDGE_ROW_7_Left_41 VGND VGND VPWR VPWR sky130_fd_sc_hd__decap_3
Xhold55 txtop.serializer.memory\[1\] VGND VGND VPWR VPWR net111 sky130_fd_sc_hd__dlygate4sd3_1
XFILLER_0_32_53 VPWR VGND VPWR VGND sky130_ef_sc_hd__decap_12
XPHY_EDGE_ROW_33_Left_67 VGND VGND VPWR VPWR sky130_fd_sc_hd__decap_3
XFILLER_0_32_3 VPWR VGND VPWR VGND sky130_ef_sc_hd__decap_12
Xoutput34 net34 VGND VGND VPWR VPWR rx_out[3] sky130_fd_sc_hd__buf_2
X_574_ clknet_3_6__leaf_clk _004_ net55 VGND VGND VPWR VPWR BRG.counter\[2\] sky130_fd_sc_hd__dfrtp_1
XTAP_TAPCELL_ROW_26_162 VGND VPWR sky130_fd_sc_hd__tapvpwrvgnd_1
XANTENNA_input16_A rx VGND VGND VPWR VPWR sky130_fd_sc_hd__diode_2
XANTENNA_input8_A div[5] VGND VGND VPWR VPWR sky130_fd_sc_hd__diode_2
XFILLER_0_7_41 VGND VGND VPWR VPWR sky130_fd_sc_hd__fill_1
XFILLER_0_7_74 VGND VGND VPWR VPWR sky130_fd_sc_hd__fill_2
X_557_ clknet_3_7__leaf_clk net89 net54 VGND VGND VPWR VPWR net33 sky130_fd_sc_hd__dfrtp_1
XTAP_TAPCELL_ROW_23_154 VGND VPWR sky130_fd_sc_hd__tapvpwrvgnd_1
X_290_ net108 _075_ _080_ VGND VGND VPWR VPWR _081_ sky130_fd_sc_hd__o21ai_1
XTAP_TAPCELL_ROW_14_121 VGND VPWR sky130_fd_sc_hd__tapvpwrvgnd_1
X_488_ _228_ _231_ _078_ VGND VGND VPWR VPWR _234_ sky130_fd_sc_hd__a21oi_1
XFILLER_0_1_167 VGND VGND VPWR VPWR sky130_fd_sc_hd__fill_1
X_411_ _167_ _181_ _182_ VGND VGND VPWR VPWR _010_ sky130_fd_sc_hd__nor3_1
X_342_ _116_ _121_ _122_ VGND VGND VPWR VPWR _123_ sky130_fd_sc_hd__a21oi_1
X_273_ rxtop.fsm_rx.Current\[2\] VGND VGND VPWR VPWR _066_ sky130_fd_sc_hd__clkbuf_2
X_609_ clknet_3_7__leaf_clk net87 net54 VGND VGND VPWR VPWR rxtop.pCheck.memory\[3\]
+ sky130_fd_sc_hd__dfrtp_1
XFILLER_0_24_65 VGND VGND VPWR VPWR sky130_fd_sc_hd__decap_4
XPHY_EDGE_ROW_20_Left_54 VGND VGND VPWR VPWR sky130_fd_sc_hd__decap_3
XFILLER_0_4_53 VGND VGND VPWR VPWR sky130_fd_sc_hd__fill_2
XFILLER_0_4_75 VGND VGND VPWR VPWR sky130_fd_sc_hd__decap_8
XFILLER_0_19_10 VPWR VGND VPWR VGND sky130_ef_sc_hd__decap_12
X_325_ _102_ _107_ _108_ VGND VGND VPWR VPWR _109_ sky130_fd_sc_hd__and3_1
XTAP_TAPCELL_ROW_0_71 VGND VPWR sky130_fd_sc_hd__tapvpwrvgnd_1
XFILLER_0_10_12 VGND VGND VPWR VPWR sky130_fd_sc_hd__decap_3
XFILLER_0_33_132 VGND VGND VPWR VPWR sky130_fd_sc_hd__fill_2
Xclkload0 clknet_3_0__leaf_clk VGND VGND VPWR VPWR clkload0/Y sky130_fd_sc_hd__clkinv_2
XFILLER_0_21_44 VGND VGND VPWR VPWR sky130_fd_sc_hd__fill_2
X_308_ _066_ rxtop.fsm_rx.Current\[1\] VGND VGND VPWR VPWR _094_ sky130_fd_sc_hd__and2b_1
Xhold23 rxtop.pCheck.memory\[1\] VGND VGND VPWR VPWR net79 sky130_fd_sc_hd__dlygate4sd3_1
XFILLER_0_30_124 VGND VGND VPWR VPWR sky130_fd_sc_hd__decap_8
Xhold34 txtop.fsm_tx.BAUD_COUNTER\[1\] VGND VGND VPWR VPWR net90 sky130_fd_sc_hd__dlygate4sd3_1
Xhold12 txtop.fsm_tx.BAUD_COUNTER\[3\] VGND VGND VPWR VPWR net68 sky130_fd_sc_hd__dlygate4sd3_1
Xhold45 rxtop.fsm_rx.BAUD_COUNTER\[0\] VGND VGND VPWR VPWR net101 sky130_fd_sc_hd__dlygate4sd3_1
XFILLER_0_15_165 VGND VGND VPWR VPWR sky130_fd_sc_hd__decap_3
Xhold56 txtop.fsm_tx.Current\[1\] VGND VGND VPWR VPWR net112 sky130_fd_sc_hd__dlygate4sd3_1
X_590_ clknet_3_0__leaf_clk _033_ net45 VGND VGND VPWR VPWR txtop.serializer.memory\[1\]
+ sky130_fd_sc_hd__dfrtp_1
XFILLER_0_32_98 VGND VGND VPWR VPWR sky130_fd_sc_hd__decap_4
XFILLER_0_32_65 VGND VGND VPWR VPWR sky130_fd_sc_hd__fill_1
XFILLER_0_21_124 VPWR VGND VPWR VGND sky130_ef_sc_hd__decap_12
XFILLER_0_21_113 VGND VGND VPWR VPWR sky130_fd_sc_hd__decap_8
XFILLER_0_16_99 VPWR VGND VPWR VGND sky130_ef_sc_hd__decap_12
XANTENNA_clkbuf_0_clk_A clk VGND VGND VPWR VPWR sky130_fd_sc_hd__diode_2
XTAP_TAPCELL_ROW_6_92 VGND VPWR sky130_fd_sc_hd__tapvpwrvgnd_1
XFILLER_0_25_3 VPWR VGND VPWR VGND sky130_ef_sc_hd__decap_12
Xoutput35 net35 VGND VGND VPWR VPWR rx_out[4] sky130_fd_sc_hd__buf_2
XFILLER_0_7_140 VGND VGND VPWR VPWR sky130_fd_sc_hd__decap_4
XPHY_EDGE_ROW_28_Right_28 VGND VGND VPWR VPWR sky130_fd_sc_hd__decap_3
X_573_ clknet_3_7__leaf_clk _003_ net55 VGND VGND VPWR VPWR BRG.counter\[1\] sky130_fd_sc_hd__dfrtp_2
XTAP_TAPCELL_ROW_26_163 VGND VPWR sky130_fd_sc_hd__tapvpwrvgnd_1
XPHY_EDGE_ROW_19_Right_19 VGND VGND VPWR VPWR sky130_fd_sc_hd__decap_3
Xclkbuf_3_1__f_clk clknet_0_clk VGND VGND VPWR VPWR clknet_3_1__leaf_clk sky130_fd_sc_hd__clkbuf_16
XFILLER_0_27_65 VGND VGND VPWR VPWR sky130_fd_sc_hd__fill_1
XFILLER_0_27_43 VGND VGND VPWR VPWR sky130_fd_sc_hd__decap_8
X_556_ clknet_3_7__leaf_clk net100 net53 VGND VGND VPWR VPWR net32 sky130_fd_sc_hd__dfrtp_1
XTAP_TAPCELL_ROW_14_122 VGND VPWR sky130_fd_sc_hd__tapvpwrvgnd_1
XFILLER_0_1_102 VGND VGND VPWR VPWR sky130_fd_sc_hd__decap_8
XTAP_TAPCELL_ROW_3_82 VGND VPWR sky130_fd_sc_hd__tapvpwrvgnd_1
X_487_ _233_ VGND VGND VPWR VPWR _031_ sky130_fd_sc_hd__clkbuf_1
X_410_ BRG.counter\[7\] _178_ BRG.counter\[8\] VGND VGND VPWR VPWR _182_ sky130_fd_sc_hd__a21oi_1
X_341_ _116_ _121_ txtop.fsm_tx.Current\[1\] VGND VGND VPWR VPWR _122_ sky130_fd_sc_hd__o21ai_1
X_272_ _065_ VGND VGND VPWR VPWR net30 sky130_fd_sc_hd__inv_2
X_608_ clknet_3_7__leaf_clk net72 net54 VGND VGND VPWR VPWR rxtop.pCheck.memory\[2\]
+ sky130_fd_sc_hd__dfrtp_1
XFILLER_0_24_88 VGND VGND VPWR VPWR sky130_fd_sc_hd__decap_8
XFILLER_0_24_55 VGND VGND VPWR VPWR sky130_fd_sc_hd__decap_3
X_539_ net84 _259_ _260_ net38 VGND VGND VPWR VPWR _056_ sky130_fd_sc_hd__a22o_1
XFILLER_0_4_98 VGND VGND VPWR VPWR sky130_fd_sc_hd__fill_1
XFILLER_0_19_22 VGND VGND VPWR VPWR sky130_fd_sc_hd__decap_4
X_324_ rxtop.fsm_rx.BAUD_COUNTER\[2\] _104_ VGND VGND VPWR VPWR _108_ sky130_fd_sc_hd__nand2_1
XFILLER_0_10_24 VGND VGND VPWR VPWR sky130_fd_sc_hd__decap_4
XTAP_TAPCELL_ROW_0_72 VGND VPWR sky130_fd_sc_hd__tapvpwrvgnd_1
Xclkload1 clknet_3_1__leaf_clk VGND VGND VPWR VPWR clkload1/Y sky130_fd_sc_hd__clkinv_4
XFILLER_0_21_34 VGND VGND VPWR VPWR sky130_fd_sc_hd__decap_4
XFILLER_0_1_55 VGND VGND VPWR VPWR sky130_fd_sc_hd__fill_1
X_307_ net42 _092_ VGND VGND VPWR VPWR _093_ sky130_fd_sc_hd__and2_1
Xhold24 _050_ VGND VGND VPWR VPWR net80 sky130_fd_sc_hd__dlygate4sd3_1
Xhold13 rxtop.pCheck.memory\[0\] VGND VGND VPWR VPWR net69 sky130_fd_sc_hd__dlygate4sd3_1
Xhold57 txtop.pCalc.memory\[4\] VGND VGND VPWR VPWR net113 sky130_fd_sc_hd__dlygate4sd3_1
XFILLER_0_15_111 VGND VGND VPWR VPWR sky130_fd_sc_hd__fill_1
XFILLER_0_1_77 VGND VGND VPWR VPWR sky130_fd_sc_hd__fill_2
Xhold35 rxtop.deserializer.ptr\[2\] VGND VGND VPWR VPWR net91 sky130_fd_sc_hd__dlygate4sd3_1
Xhold46 rxtop.deserializer.ptr\[1\] VGND VGND VPWR VPWR net102 sky130_fd_sc_hd__dlygate4sd3_1
XFILLER_0_32_77 VGND VGND VPWR VPWR sky130_fd_sc_hd__decap_6
XFILLER_0_21_136 VGND VGND VPWR VPWR sky130_fd_sc_hd__decap_8
XFILLER_0_16_89 VGND VGND VPWR VPWR sky130_fd_sc_hd__decap_3
XTAP_TAPCELL_ROW_6_93 VGND VPWR sky130_fd_sc_hd__tapvpwrvgnd_1
XFILLER_0_20_180 VGND VGND VPWR VPWR sky130_fd_sc_hd__decap_4
XFILLER_0_18_3 VGND VGND VPWR VPWR sky130_fd_sc_hd__fill_2
XFILLER_0_12_169 VGND VGND VPWR VPWR sky130_fd_sc_hd__decap_8
XFILLER_0_12_147 VPWR VGND VPWR VGND sky130_ef_sc_hd__decap_12
XTAP_TAPCELL_ROW_26_164 VGND VPWR sky130_fd_sc_hd__tapvpwrvgnd_1
X_572_ clknet_3_6__leaf_clk _000_ net55 VGND VGND VPWR VPWR BRG.counter\[0\] sky130_fd_sc_hd__dfrtp_2
Xoutput36 net36 VGND VGND VPWR VPWR rx_out[5] sky130_fd_sc_hd__buf_2
XFILLER_0_9_6 VGND VGND VPWR VPWR sky130_fd_sc_hd__fill_2
XFILLER_0_27_55 VGND VGND VPWR VPWR sky130_fd_sc_hd__fill_1
XTAP_TAPCELL_ROW_17_131 VGND VPWR sky130_fd_sc_hd__tapvpwrvgnd_1
XFILLER_0_4_122 VPWR VGND VPWR VGND sky130_ef_sc_hd__decap_12
XFILLER_0_7_3 VGND VGND VPWR VPWR sky130_fd_sc_hd__fill_2
X_555_ clknet_3_7__leaf_clk net82 net53 VGND VGND VPWR VPWR net31 sky130_fd_sc_hd__dfrtp_1
XTAP_TAPCELL_ROW_14_123 VGND VPWR sky130_fd_sc_hd__tapvpwrvgnd_1
XFILLER_0_13_57 VPWR VGND VPWR VGND sky130_ef_sc_hd__decap_12
XANTENNA_input21_A tx_in[3] VGND VGND VPWR VPWR sky130_fd_sc_hd__diode_2
XTAP_TAPCELL_ROW_3_83 VGND VPWR sky130_fd_sc_hd__tapvpwrvgnd_1
X_486_ txtop.fsm_tx.Current\[2\] _232_ _229_ VGND VGND VPWR VPWR _233_ sky130_fd_sc_hd__mux2_1
X_607_ clknet_3_7__leaf_clk net80 net54 VGND VGND VPWR VPWR rxtop.pCheck.memory\[1\]
+ sky130_fd_sc_hd__dfrtp_1
XFILLER_0_24_78 VGND VGND VPWR VPWR sky130_fd_sc_hd__decap_6
X_538_ net77 _259_ _260_ net37 VGND VGND VPWR VPWR _055_ sky130_fd_sc_hd__a22o_1
X_340_ _119_ _120_ VGND VGND VPWR VPWR _121_ sky130_fd_sc_hd__xnor2_1
X_271_ net43 _064_ VGND VGND VPWR VPWR _065_ sky130_fd_sc_hd__nand2_1
X_469_ _219_ _213_ _220_ _215_ net102 VGND VGND VPWR VPWR _026_ sky130_fd_sc_hd__a32o_1
X_323_ rxtop.fsm_rx.BAUD_COUNTER\[2\] _104_ VGND VGND VPWR VPWR _107_ sky130_fd_sc_hd__or2_1
XFILLER_0_19_78 VGND VGND VPWR VPWR sky130_fd_sc_hd__fill_2
XFILLER_0_10_58 VGND VGND VPWR VPWR sky130_fd_sc_hd__decap_8
XTAP_TAPCELL_ROW_0_73 VGND VPWR sky130_fd_sc_hd__tapvpwrvgnd_1
XFILLER_0_33_167 VGND VGND VPWR VPWR sky130_fd_sc_hd__fill_1
XFILLER_0_33_145 VPWR VGND VPWR VGND sky130_ef_sc_hd__decap_12
Xclkload2 clknet_3_2__leaf_clk VGND VGND VPWR VPWR clkload2/Y sky130_fd_sc_hd__clkinvlp_4
XFILLER_0_18_197 VGND VGND VPWR VPWR sky130_fd_sc_hd__fill_1
XFILLER_0_21_57 VPWR VGND VPWR VGND sky130_ef_sc_hd__decap_12
X_306_ rxtop.deserializer.ptr\[1\] rxtop.deserializer.ptr\[0\] rxtop.deserializer.ptr\[2\]
+ rxtop.deserializer.ptr\[3\] VGND VGND VPWR VPWR _092_ sky130_fd_sc_hd__or4b_2
XANTENNA_clkbuf_3_4__f_clk_A clknet_0_clk VGND VGND VPWR VPWR sky130_fd_sc_hd__diode_2
Xhold25 net31 VGND VGND VPWR VPWR net81 sky130_fd_sc_hd__dlygate4sd3_1
Xhold14 _049_ VGND VGND VPWR VPWR net70 sky130_fd_sc_hd__dlygate4sd3_1
Xhold58 rxtop.fsm_rx.BAUD_COUNTER\[4\] VGND VGND VPWR VPWR net114 sky130_fd_sc_hd__dlygate4sd3_1
Xhold36 txtop.serializer.ptr\[3\] VGND VGND VPWR VPWR net92 sky130_fd_sc_hd__dlygate4sd3_1
Xhold47 txtop.data_mux_wire VGND VGND VPWR VPWR net103 sky130_fd_sc_hd__dlygate4sd3_1
XTAP_TAPCELL_ROW_29_173 VGND VPWR sky130_fd_sc_hd__tapvpwrvgnd_1
XFILLER_0_20_192 VGND VGND VPWR VPWR sky130_fd_sc_hd__decap_4
XFILLER_0_12_159 VGND VGND VPWR VPWR sky130_fd_sc_hd__decap_3
XTAP_TAPCELL_ROW_6_94 VGND VPWR sky130_fd_sc_hd__tapvpwrvgnd_1
XTAP_TAPCELL_ROW_26_165 VGND VPWR sky130_fd_sc_hd__tapvpwrvgnd_1
Xoutput37 net37 VGND VGND VPWR VPWR rx_out[6] sky130_fd_sc_hd__buf_2
X_571_ clknet_3_5__leaf_clk rxtop.fsm_rx.BAUD_COUNTER_Next\[4\] net51 VGND VGND VPWR
+ VPWR rxtop.fsm_rx.BAUD_COUNTER\[4\] sky130_fd_sc_hd__dfrtp_1
Xoutput26 net26 VGND VGND VPWR VPWR framingError sky130_fd_sc_hd__buf_2
XPHY_EDGE_ROW_1_Right_1 VGND VGND VPWR VPWR sky130_fd_sc_hd__decap_3
XFILLER_0_7_164 VGND VGND VPWR VPWR sky130_fd_sc_hd__fill_1
XFILLER_0_7_175 VPWR VGND VPWR VGND sky130_ef_sc_hd__decap_12
XTAP_TAPCELL_ROW_17_132 VGND VPWR sky130_fd_sc_hd__tapvpwrvgnd_1
XFILLER_0_4_134 VGND VGND VPWR VPWR sky130_fd_sc_hd__decap_6
XFILLER_0_7_11 VGND VGND VPWR VPWR sky130_fd_sc_hd__decap_4
XFILLER_0_30_3 VGND VGND VPWR VPWR sky130_fd_sc_hd__fill_2
XFILLER_0_7_55 VGND VGND VPWR VPWR sky130_fd_sc_hd__fill_1
XTAP_TAPCELL_ROW_8_100 VGND VPWR sky130_fd_sc_hd__tapvpwrvgnd_1
XFILLER_0_13_69 VPWR VGND VPWR VGND sky130_ef_sc_hd__decap_12
XANTENNA_input14_A parityType VGND VGND VPWR VPWR sky130_fd_sc_hd__diode_2
XTAP_TAPCELL_ROW_3_84 VGND VPWR sky130_fd_sc_hd__tapvpwrvgnd_1
X_485_ txtop.fsm_tx.Current\[0\] _226_ _076_ txtop.fsm_tx.Current\[1\] VGND VGND VPWR
+ VPWR _232_ sky130_fd_sc_hd__o211a_1
X_554_ clknet_3_5__leaf_clk _016_ net51 VGND VGND VPWR VPWR net28 sky130_fd_sc_hd__dfrtp_1
XANTENNA_input6_A div[3] VGND VGND VPWR VPWR sky130_fd_sc_hd__diode_2
XFILLER_0_0_181 VPWR VGND VPWR VGND sky130_ef_sc_hd__decap_12
X_270_ rxtop.fsm_rx.Current\[1\] rxtop.fsm_rx.Current\[0\] rxtop.fsm_rx.Current\[2\]
+ VGND VGND VPWR VPWR _064_ sky130_fd_sc_hd__nor3b_2
X_606_ clknet_3_7__leaf_clk net70 net54 VGND VGND VPWR VPWR rxtop.pCheck.memory\[0\]
+ sky130_fd_sc_hd__dfrtp_1
X_399_ BRG.counter\[4\] _173_ VGND VGND VPWR VPWR _175_ sky130_fd_sc_hd__xnor2_1
X_537_ net73 _259_ _260_ net36 VGND VGND VPWR VPWR _054_ sky130_fd_sc_hd__a22o_1
XFILLER_0_4_23 VGND VGND VPWR VPWR sky130_fd_sc_hd__decap_4
X_468_ rxtop.deserializer.ptr\[1\] rxtop.deserializer.ptr\[0\] VGND VGND VPWR VPWR
+ _220_ sky130_fd_sc_hd__nand2_1
X_322_ _106_ VGND VGND VPWR VPWR rxtop.fsm_rx.BAUD_COUNTER_Next\[1\] sky130_fd_sc_hd__clkbuf_1
XPHY_EDGE_ROW_24_Left_58 VGND VGND VPWR VPWR sky130_fd_sc_hd__decap_3
Xclkbuf_3_7__f_clk clknet_0_clk VGND VGND VPWR VPWR clknet_3_7__leaf_clk sky130_fd_sc_hd__clkbuf_16
XTAP_TAPCELL_ROW_0_74 VGND VPWR sky130_fd_sc_hd__tapvpwrvgnd_1
Xfanout50 net52 VGND VGND VPWR VPWR net50 sky130_fd_sc_hd__buf_2
XFILLER_0_33_113 VGND VGND VPWR VPWR sky130_fd_sc_hd__fill_2
Xclkload3 clknet_3_3__leaf_clk VGND VGND VPWR VPWR clkload3/Y sky130_fd_sc_hd__clkinv_4
XFILLER_0_21_69 VGND VGND VPWR VPWR sky130_fd_sc_hd__fill_1
X_305_ _091_ VGND VGND VPWR VPWR txtop.fsm_tx.BAUD_COUNTER_Next\[4\] sky130_fd_sc_hd__clkbuf_1
XFILLER_0_30_105 VGND VGND VPWR VPWR sky130_fd_sc_hd__fill_1
XFILLER_0_15_113 VPWR VGND VPWR VGND sky130_ef_sc_hd__decap_12
Xhold26 _017_ VGND VGND VPWR VPWR net82 sky130_fd_sc_hd__dlygate4sd3_1
Xhold15 rxtop.pCheck.memory\[2\] VGND VGND VPWR VPWR net71 sky130_fd_sc_hd__dlygate4sd3_1
Xhold59 BRG.counter\[7\] VGND VGND VPWR VPWR net115 sky130_fd_sc_hd__dlygate4sd3_1
Xhold48 txtop.serializer.ptr\[2\] VGND VGND VPWR VPWR net104 sky130_fd_sc_hd__dlygate4sd3_1
Xhold37 _265_ VGND VGND VPWR VPWR net93 sky130_fd_sc_hd__dlygate4sd3_1
XTAP_TAPCELL_ROW_29_174 VGND VPWR sky130_fd_sc_hd__tapvpwrvgnd_1
XPHY_EDGE_ROW_27_Left_61 VGND VGND VPWR VPWR sky130_fd_sc_hd__decap_3
XFILLER_0_16_25 VGND VGND VPWR VPWR sky130_fd_sc_hd__decap_3
XPHY_EDGE_ROW_11_Left_45 VGND VGND VPWR VPWR sky130_fd_sc_hd__decap_3
XTAP_TAPCELL_ROW_6_95 VGND VPWR sky130_fd_sc_hd__tapvpwrvgnd_1
Xoutput38 net38 VGND VGND VPWR VPWR rx_out[7] sky130_fd_sc_hd__buf_2
X_570_ clknet_3_4__leaf_clk rxtop.fsm_rx.BAUD_COUNTER_Next\[3\] net50 VGND VGND VPWR
+ VPWR rxtop.fsm_rx.BAUD_COUNTER\[3\] sky130_fd_sc_hd__dfrtp_1
Xoutput27 net27 VGND VGND VPWR VPWR parityError sky130_fd_sc_hd__buf_2
XFILLER_0_7_110 VGND VGND VPWR VPWR sky130_fd_sc_hd__fill_2
XFILLER_0_7_121 VGND VGND VPWR VPWR sky130_fd_sc_hd__fill_1
XFILLER_0_27_57 VGND VGND VPWR VPWR sky130_fd_sc_hd__decap_8
XTAP_TAPCELL_ROW_17_133 VGND VPWR sky130_fd_sc_hd__tapvpwrvgnd_1
Xclkbuf_0_clk clk VGND VGND VPWR VPWR clknet_0_clk sky130_fd_sc_hd__clkbuf_16
XPHY_EDGE_ROW_24_Right_24 VGND VGND VPWR VPWR sky130_fd_sc_hd__decap_3
XFILLER_0_23_3 VGND VGND VPWR VPWR sky130_fd_sc_hd__decap_6
XPHY_EDGE_ROW_15_Right_15 VGND VGND VPWR VPWR sky130_fd_sc_hd__decap_3
XPHY_EDGE_ROW_33_Right_33 VGND VGND VPWR VPWR sky130_fd_sc_hd__decap_3
XTAP_TAPCELL_ROW_31_180 VGND VPWR sky130_fd_sc_hd__tapvpwrvgnd_1
XFILLER_0_13_48 VGND VGND VPWR VPWR sky130_fd_sc_hd__decap_8
X_553_ clknet_3_5__leaf_clk _015_ net51 VGND VGND VPWR VPWR net27 sky130_fd_sc_hd__dfrtp_1
X_622_ clknet_3_4__leaf_clk _060_ net50 VGND VGND VPWR VPWR txtop.serializer.ptr\[3\]
+ sky130_fd_sc_hd__dfrtp_1
X_484_ _230_ _231_ net112 _229_ VGND VGND VPWR VPWR _030_ sky130_fd_sc_hd__o2bb2a_1
XTAP_TAPCELL_ROW_8_101 VGND VPWR sky130_fd_sc_hd__tapvpwrvgnd_1
XFILLER_0_0_193 VGND VGND VPWR VPWR sky130_fd_sc_hd__fill_1
XFILLER_0_24_69 VGND VGND VPWR VPWR sky130_fd_sc_hd__fill_1
X_398_ _168_ _173_ _174_ VGND VGND VPWR VPWR _005_ sky130_fd_sc_hd__nor3_1
X_536_ net75 _259_ _260_ net35 VGND VGND VPWR VPWR _053_ sky130_fd_sc_hd__a22o_1
X_467_ rxtop.deserializer.ptr\[1\] rxtop.deserializer.ptr\[0\] VGND VGND VPWR VPWR
+ _219_ sky130_fd_sc_hd__or2_1
X_605_ clknet_3_1__leaf_clk _048_ net46 VGND VGND VPWR VPWR txtop.data_mux_wire sky130_fd_sc_hd__dfrtp_1
X_321_ _102_ _103_ _105_ VGND VGND VPWR VPWR _106_ sky130_fd_sc_hd__and3_1
XFILLER_0_10_49 VGND VGND VPWR VPWR sky130_fd_sc_hd__decap_6
Xfanout51 net52 VGND VGND VPWR VPWR net51 sky130_fd_sc_hd__buf_2
XFILLER_0_18_144 VGND VGND VPWR VPWR sky130_fd_sc_hd__decap_4
X_519_ _253_ VGND VGND VPWR VPWR _043_ sky130_fd_sc_hd__clkbuf_1
XFILLER_0_33_125 VGND VGND VPWR VPWR sky130_fd_sc_hd__fill_2
X_304_ _080_ _089_ _090_ VGND VGND VPWR VPWR _091_ sky130_fd_sc_hd__and3_1
Xclkload4 clknet_3_4__leaf_clk VGND VGND VPWR VPWR clkload4/Y sky130_fd_sc_hd__clkinvlp_4
XFILLER_0_15_169 VGND VGND VPWR VPWR sky130_fd_sc_hd__fill_2
XFILLER_0_15_136 VGND VGND VPWR VPWR sky130_fd_sc_hd__fill_1
XFILLER_0_15_125 VGND VGND VPWR VPWR sky130_fd_sc_hd__decap_8
XFILLER_0_15_103 VGND VGND VPWR VPWR sky130_fd_sc_hd__decap_8
Xhold16 _051_ VGND VGND VPWR VPWR net72 sky130_fd_sc_hd__dlygate4sd3_1
Xhold27 BRG.counter\[0\] VGND VGND VPWR VPWR net83 sky130_fd_sc_hd__dlygate4sd3_1
Xhold38 net37 VGND VGND VPWR VPWR net94 sky130_fd_sc_hd__dlygate4sd3_1
Xhold49 txtop.serializer.ptr\[1\] VGND VGND VPWR VPWR net105 sky130_fd_sc_hd__dlygate4sd3_1
XTAP_TAPCELL_ROW_29_175 VGND VPWR sky130_fd_sc_hd__tapvpwrvgnd_1
XFILLER_0_12_139 VGND VGND VPWR VPWR sky130_fd_sc_hd__fill_1
Xoutput39 net39 VGND VGND VPWR VPWR tx sky130_fd_sc_hd__buf_2
XFILLER_0_7_144 VGND VGND VPWR VPWR sky130_fd_sc_hd__fill_1
Xoutput28 net28 VGND VGND VPWR VPWR parityErrorValid sky130_fd_sc_hd__buf_2
XFILLER_0_33_90 VGND VGND VPWR VPWR sky130_fd_sc_hd__fill_2
XTAP_TAPCELL_ROW_31_181 VGND VPWR sky130_fd_sc_hd__tapvpwrvgnd_1
X_621_ clknet_3_1__leaf_clk _059_ net49 VGND VGND VPWR VPWR txtop.serializer.ptr\[2\]
+ sky130_fd_sc_hd__dfrtp_1
X_552_ clknet_3_5__leaf_clk _014_ net50 VGND VGND VPWR VPWR rxtop.fsm_rx.Current\[2\]
+ sky130_fd_sc_hd__dfrtp_1
X_483_ txtop.fsm_tx.Current\[2\] txtop.fsm_tx.Current\[1\] _114_ VGND VGND VPWR VPWR
+ _231_ sky130_fd_sc_hd__or3_1
XTAP_TAPCELL_ROW_8_102 VGND VPWR sky130_fd_sc_hd__tapvpwrvgnd_1
XFILLER_0_22_201 VGND VGND VPWR VPWR sky130_fd_sc_hd__fill_1
X_535_ net86 _259_ _260_ net34 VGND VGND VPWR VPWR _052_ sky130_fd_sc_hd__a22o_1
X_397_ BRG.counter\[3\] _170_ VGND VGND VPWR VPWR _174_ sky130_fd_sc_hd__nor2_1
X_604_ clknet_3_2__leaf_clk _047_ net47 VGND VGND VPWR VPWR txtop.pCalc.memory\[7\]
+ sky130_fd_sc_hd__dfrtp_1
X_466_ _218_ VGND VGND VPWR VPWR _025_ sky130_fd_sc_hd__clkbuf_1
XFILLER_0_5_3 VGND VGND VPWR VPWR sky130_fd_sc_hd__decap_4
X_320_ _104_ VGND VGND VPWR VPWR _105_ sky130_fd_sc_hd__inv_2
Xfanout52 net56 VGND VGND VPWR VPWR net52 sky130_fd_sc_hd__clkbuf_2
XFILLER_0_27_167 VGND VGND VPWR VPWR sky130_fd_sc_hd__fill_1
X_449_ _206_ _209_ _211_ VGND VGND VPWR VPWR _212_ sky130_fd_sc_hd__o21a_1
X_518_ net117 net21 _249_ VGND VGND VPWR VPWR _253_ sky130_fd_sc_hd__mux2_1
XFILLER_0_2_201 VGND VGND VPWR VPWR sky130_fd_sc_hd__fill_1
Xclkload5 clknet_3_5__leaf_clk VGND VGND VPWR VPWR clkload5/Y sky130_fd_sc_hd__clkinv_2
XFILLER_0_32_192 VGND VGND VPWR VPWR sky130_fd_sc_hd__decap_4
X_303_ txtop.fsm_tx.BAUD_COUNTER\[3\] txtop.fsm_tx.BAUD_COUNTER\[4\] _087_ VGND VGND
+ VPWR VPWR _090_ sky130_fd_sc_hd__nand3_1
Xhold17 rxtop.pCheck.memory\[5\] VGND VGND VPWR VPWR net73 sky130_fd_sc_hd__dlygate4sd3_1
Xhold39 _022_ VGND VGND VPWR VPWR net95 sky130_fd_sc_hd__dlygate4sd3_1
Xhold28 rxtop.pCheck.memory\[7\] VGND VGND VPWR VPWR net84 sky130_fd_sc_hd__dlygate4sd3_1
XFILLER_0_11_93 VPWR VGND VPWR VGND sky130_ef_sc_hd__decap_12
XFILLER_0_32_15 VPWR VGND VPWR VGND sky130_ef_sc_hd__decap_12
XFILLER_0_22_92 VGND VGND VPWR VPWR sky130_fd_sc_hd__fill_2
XFILLER_0_18_7 VGND VGND VPWR VPWR sky130_fd_sc_hd__fill_2
XFILLER_0_11_140 VGND VGND VPWR VPWR sky130_fd_sc_hd__decap_3
Xoutput29 net29 VGND VGND VPWR VPWR rx_busy sky130_fd_sc_hd__buf_2
XFILLER_0_4_159 VPWR VGND VPWR VGND sky130_ef_sc_hd__decap_12
XFILLER_0_7_25 VGND VGND VPWR VPWR sky130_fd_sc_hd__decap_8
XTAP_TAPCELL_ROW_31_182 VGND VPWR sky130_fd_sc_hd__tapvpwrvgnd_1
X_620_ clknet_3_1__leaf_clk _058_ net49 VGND VGND VPWR VPWR txtop.serializer.ptr\[1\]
+ sky130_fd_sc_hd__dfrtp_1
X_551_ clknet_3_4__leaf_clk _013_ net50 VGND VGND VPWR VPWR rxtop.fsm_rx.Current\[1\]
+ sky130_fd_sc_hd__dfrtp_2
XPHY_EDGE_ROW_5_Right_5 VGND VGND VPWR VPWR sky130_fd_sc_hd__decap_3
XFILLER_0_7_7 VGND VGND VPWR VPWR sky130_fd_sc_hd__fill_1
X_482_ _084_ _230_ _229_ net110 VGND VGND VPWR VPWR _029_ sky130_fd_sc_hd__o2bb2a_1
XANTENNA_input12_A div[9] VGND VGND VPWR VPWR sky130_fd_sc_hd__diode_2
X_534_ net71 _259_ _260_ net33 VGND VGND VPWR VPWR _051_ sky130_fd_sc_hd__a22o_1
X_396_ _172_ VGND VGND VPWR VPWR _173_ sky130_fd_sc_hd__dlymetal6s2s_1
XANTENNA_clkbuf_3_7__f_clk_A clknet_0_clk VGND VGND VPWR VPWR sky130_fd_sc_hd__diode_2
X_603_ clknet_3_2__leaf_clk _046_ net47 VGND VGND VPWR VPWR txtop.pCalc.memory\[6\]
+ sky130_fd_sc_hd__dfrtp_1
X_465_ _217_ rxtop.deserializer.ptr\[0\] _215_ VGND VGND VPWR VPWR _218_ sky130_fd_sc_hd__mux2_1
XFILLER_0_14_82 VGND VGND VPWR VPWR sky130_fd_sc_hd__fill_2
XANTENNA_input4_A div[1] VGND VGND VPWR VPWR sky130_fd_sc_hd__diode_2
Xfanout53 net56 VGND VGND VPWR VPWR net53 sky130_fd_sc_hd__buf_2
X_379_ _154_ _155_ _158_ VGND VGND VPWR VPWR _159_ sky130_fd_sc_hd__mux2_1
X_448_ _068_ net43 _094_ VGND VGND VPWR VPWR _211_ sky130_fd_sc_hd__and3_1
X_517_ _252_ VGND VGND VPWR VPWR _042_ sky130_fd_sc_hd__clkbuf_1
XFILLER_0_25_81 VPWR VGND VPWR VGND sky130_ef_sc_hd__decap_12
Xclkload6 clknet_3_6__leaf_clk VGND VGND VPWR VPWR clkload6/Y sky130_fd_sc_hd__clkinv_2
X_302_ txtop.fsm_tx.BAUD_COUNTER\[3\] txtop.fsm_tx.BAUD_COUNTER\[2\] _083_ txtop.fsm_tx.BAUD_COUNTER\[4\]
+ VGND VGND VPWR VPWR _089_ sky130_fd_sc_hd__a31o_1
Xhold18 _054_ VGND VGND VPWR VPWR net74 sky130_fd_sc_hd__dlygate4sd3_1
Xhold29 _056_ VGND VGND VPWR VPWR net85 sky130_fd_sc_hd__dlygate4sd3_1
XFILLER_0_32_27 VGND VGND VPWR VPWR sky130_fd_sc_hd__fill_1
XFILLER_0_14_160 VGND VGND VPWR VPWR sky130_fd_sc_hd__fill_1
XFILLER_0_20_141 VPWR VGND VPWR VGND sky130_ef_sc_hd__decap_12
XFILLER_0_20_130 VGND VGND VPWR VPWR sky130_fd_sc_hd__decap_3
XFILLER_0_11_174 VGND VGND VPWR VPWR sky130_fd_sc_hd__decap_4
XPHY_EDGE_ROW_15_Left_49 VGND VGND VPWR VPWR sky130_fd_sc_hd__decap_3
XFILLER_0_7_15 VGND VGND VPWR VPWR sky130_fd_sc_hd__fill_1
XFILLER_0_30_7 VGND VGND VPWR VPWR sky130_fd_sc_hd__decap_4
XTAP_TAPCELL_ROW_22_150 VGND VPWR sky130_fd_sc_hd__tapvpwrvgnd_1
XPHY_EDGE_ROW_20_Right_20 VGND VGND VPWR VPWR sky130_fd_sc_hd__decap_3
XPHY_EDGE_ROW_11_Right_11 VGND VGND VPWR VPWR sky130_fd_sc_hd__decap_3
X_550_ clknet_3_4__leaf_clk _012_ net50 VGND VGND VPWR VPWR rxtop.fsm_rx.Current\[0\]
+ sky130_fd_sc_hd__dfrtp_1
X_481_ _226_ _124_ _229_ VGND VGND VPWR VPWR _230_ sky130_fd_sc_hd__o21a_1
XFILLER_0_0_141 VGND VGND VPWR VPWR sky130_fd_sc_hd__decap_8
X_533_ net79 _259_ _260_ net32 VGND VGND VPWR VPWR _050_ sky130_fd_sc_hd__a22o_1
X_602_ clknet_3_2__leaf_clk _045_ net47 VGND VGND VPWR VPWR txtop.pCalc.memory\[5\]
+ sky130_fd_sc_hd__dfrtp_1
X_464_ _066_ rxtop.deserializer.ptr\[0\] VGND VGND VPWR VPWR _217_ sky130_fd_sc_hd__nor2_1
X_395_ BRG.counter\[1\] BRG.counter\[0\] BRG.counter\[3\] BRG.counter\[2\] VGND VGND
+ VPWR VPWR _172_ sky130_fd_sc_hd__and4_1
Xclkbuf_3_2__f_clk clknet_0_clk VGND VGND VPWR VPWR clknet_3_2__leaf_clk sky130_fd_sc_hd__clkbuf_16
XFILLER_0_4_27 VGND VGND VPWR VPWR sky130_fd_sc_hd__fill_1
Xfanout54 net56 VGND VGND VPWR VPWR net54 sky130_fd_sc_hd__clkbuf_2
XPHY_EDGE_ROW_18_Left_52 VGND VGND VPWR VPWR sky130_fd_sc_hd__decap_3
X_378_ net44 _156_ _152_ _157_ BRG.counter\[6\] VGND VGND VPWR VPWR _158_ sky130_fd_sc_hd__a32o_1
XFILLER_0_27_169 VGND VGND VPWR VPWR sky130_fd_sc_hd__decap_6
X_447_ _206_ _209_ VGND VGND VPWR VPWR _210_ sky130_fd_sc_hd__nand2_1
X_516_ txtop.pCalc.memory\[2\] net20 _249_ VGND VGND VPWR VPWR _252_ sky130_fd_sc_hd__mux2_1
XFILLER_0_33_139 VGND VGND VPWR VPWR sky130_fd_sc_hd__fill_1
XFILLER_0_33_106 VGND VGND VPWR VPWR sky130_fd_sc_hd__decap_6
XFILLER_0_25_93 VPWR VGND VPWR VGND sky130_ef_sc_hd__decap_12
XPHY_EDGE_ROW_3_Left_37 VGND VGND VPWR VPWR sky130_fd_sc_hd__decap_3
X_301_ net68 _087_ _088_ VGND VGND VPWR VPWR txtop.fsm_tx.BAUD_COUNTER_Next\[3\] sky130_fd_sc_hd__a21oi_1
Xhold19 rxtop.pCheck.memory\[4\] VGND VGND VPWR VPWR net75 sky130_fd_sc_hd__dlygate4sd3_1
XFILLER_0_16_29 VGND VGND VPWR VPWR sky130_fd_sc_hd__fill_1
XFILLER_0_20_197 VGND VGND VPWR VPWR sky130_fd_sc_hd__fill_1
XFILLER_0_12_109 VPWR VGND VPWR VGND sky130_ef_sc_hd__decap_12
XFILLER_0_22_83 VGND VGND VPWR VPWR sky130_fd_sc_hd__fill_1
XFILLER_0_7_169 VGND VGND VPWR VPWR sky130_fd_sc_hd__decap_3
XFILLER_0_27_28 VGND VGND VPWR VPWR sky130_fd_sc_hd__fill_2
XPHY_EDGE_ROW_6_Left_40 VGND VGND VPWR VPWR sky130_fd_sc_hd__decap_3
XFILLER_0_17_83 VGND VGND VPWR VPWR sky130_fd_sc_hd__fill_2
XFILLER_0_16_201 VGND VGND VPWR VPWR sky130_fd_sc_hd__fill_1
XFILLER_0_16_6 VGND VGND VPWR VPWR sky130_fd_sc_hd__fill_2
XPHY_EDGE_ROW_32_Left_66 VGND VGND VPWR VPWR sky130_fd_sc_hd__decap_3
XTAP_TAPCELL_ROW_22_151 VGND VPWR sky130_fd_sc_hd__tapvpwrvgnd_1
XFILLER_0_13_19 VGND VGND VPWR VPWR sky130_fd_sc_hd__fill_2
X_480_ net17 _084_ _228_ _079_ VGND VGND VPWR VPWR _229_ sky130_fd_sc_hd__o211a_1
XFILLER_0_28_82 VGND VGND VPWR VPWR sky130_fd_sc_hd__fill_2
XFILLER_0_28_60 VPWR VGND VPWR VGND sky130_ef_sc_hd__decap_12
XFILLER_0_0_197 VGND VGND VPWR VPWR sky130_fd_sc_hd__fill_2
X_601_ clknet_3_2__leaf_clk _044_ net47 VGND VGND VPWR VPWR txtop.pCalc.memory\[4\]
+ sky130_fd_sc_hd__dfrtp_1
XFILLER_0_8_92 VGND VGND VPWR VPWR sky130_fd_sc_hd__decap_4
X_532_ net69 _259_ _260_ net31 VGND VGND VPWR VPWR _049_ sky130_fd_sc_hd__a22o_1
X_394_ _168_ _170_ _171_ VGND VGND VPWR VPWR _004_ sky130_fd_sc_hd__nor3_1
XFILLER_0_24_29 VGND VGND VPWR VPWR sky130_fd_sc_hd__decap_3
X_463_ rx_synchronizer.rx_out _214_ _216_ net96 VGND VGND VPWR VPWR _024_ sky130_fd_sc_hd__a22o_1
Xfanout55 net56 VGND VGND VPWR VPWR net55 sky130_fd_sc_hd__buf_2
X_377_ net9 VGND VGND VPWR VPWR _157_ sky130_fd_sc_hd__inv_2
X_446_ _207_ _208_ VGND VGND VPWR VPWR _209_ sky130_fd_sc_hd__xnor2_1
XTAP_TAPCELL_ROW_0_68 VGND VPWR sky130_fd_sc_hd__tapvpwrvgnd_1
XFILLER_0_3_3 VPWR VGND VPWR VGND sky130_ef_sc_hd__decap_12
X_515_ _251_ VGND VGND VPWR VPWR _041_ sky130_fd_sc_hd__clkbuf_1
XFILLER_0_33_118 VGND VGND VPWR VPWR sky130_fd_sc_hd__fill_2
XFILLER_0_24_118 VGND VGND VPWR VPWR sky130_fd_sc_hd__fill_2
X_300_ net68 _087_ _084_ VGND VGND VPWR VPWR _088_ sky130_fd_sc_hd__o21ai_1
X_429_ _098_ _193_ net43 _194_ VGND VGND VPWR VPWR _195_ sky130_fd_sc_hd__o2bb2a_1
Xinput1 div[0] VGND VGND VPWR VPWR net1 sky130_fd_sc_hd__buf_1
XFILLER_0_14_195 VGND VGND VPWR VPWR sky130_fd_sc_hd__fill_1
XFILLER_0_32_29 VGND VGND VPWR VPWR sky130_fd_sc_hd__decap_3
XFILLER_0_22_62 VGND VGND VPWR VPWR sky130_fd_sc_hd__fill_2
XTAP_TAPCELL_ROW_25_160 VGND VPWR sky130_fd_sc_hd__tapvpwrvgnd_1
XFILLER_0_33_94 VPWR VGND VPWR VGND sky130_ef_sc_hd__decap_12
XFILLER_0_33_83 VGND VGND VPWR VPWR sky130_fd_sc_hd__fill_1
XFILLER_0_4_107 VPWR VGND VPWR VGND sky130_ef_sc_hd__decap_12
XFILLER_0_0_154 VPWR VGND VPWR VGND sky130_ef_sc_hd__decap_12
XFILLER_0_0_132 VGND VGND VPWR VPWR sky130_fd_sc_hd__decap_8
XPHY_EDGE_ROW_9_Right_9 VGND VGND VPWR VPWR sky130_fd_sc_hd__decap_3
XFILLER_0_28_72 VGND VGND VPWR VPWR sky130_fd_sc_hd__decap_4
XFILLER_0_5_7 VGND VGND VPWR VPWR sky130_fd_sc_hd__fill_1
XFILLER_0_8_82 VGND VGND VPWR VPWR sky130_fd_sc_hd__fill_2
X_393_ BRG.counter\[1\] BRG.counter\[0\] BRG.counter\[2\] VGND VGND VPWR VPWR _171_
+ sky130_fd_sc_hd__a21oi_1
X_462_ net96 _214_ _216_ net94 VGND VGND VPWR VPWR _023_ sky130_fd_sc_hd__a22o_1
X_600_ clknet_3_0__leaf_clk _043_ net45 VGND VGND VPWR VPWR txtop.pCalc.memory\[3\]
+ sky130_fd_sc_hd__dfrtp_1
X_531_ net30 _092_ VGND VGND VPWR VPWR _260_ sky130_fd_sc_hd__nor2_2
XFILLER_0_14_74 VGND VGND VPWR VPWR sky130_fd_sc_hd__decap_8
XANTENNA_input10_A div[7] VGND VGND VPWR VPWR sky130_fd_sc_hd__diode_2
XTAP_TAPCELL_ROW_0_69 VGND VPWR sky130_fd_sc_hd__tapvpwrvgnd_1
Xfanout45 net46 VGND VGND VPWR VPWR net45 sky130_fd_sc_hd__buf_2
Xfanout56 net15 VGND VGND VPWR VPWR net56 sky130_fd_sc_hd__buf_1
X_514_ txtop.pCalc.memory\[1\] net19 _249_ VGND VGND VPWR VPWR _251_ sky130_fd_sc_hd__mux2_1
X_376_ net7 net8 VGND VGND VPWR VPWR _156_ sky130_fd_sc_hd__nor2_1
X_445_ rxtop.pCheck.memory\[5\] rxtop.pCheck.memory\[4\] VGND VGND VPWR VPWR _208_
+ sky130_fd_sc_hd__xor2_1
XANTENNA_input2_A div[10] VGND VGND VPWR VPWR sky130_fd_sc_hd__diode_2
XFILLER_0_17_182 VGND VGND VPWR VPWR sky130_fd_sc_hd__fill_2
XFILLER_0_5_83 VGND VGND VPWR VPWR sky130_fd_sc_hd__decap_8
XFILLER_0_32_141 VPWR VGND VPWR VGND sky130_ef_sc_hd__decap_12
X_359_ net6 _138_ VGND VGND VPWR VPWR _139_ sky130_fd_sc_hd__xor2_1
XFILLER_0_23_141 VPWR VGND VPWR VGND sky130_ef_sc_hd__decap_12
XFILLER_0_11_64 VGND VGND VPWR VPWR sky130_fd_sc_hd__decap_4
X_428_ _095_ VGND VGND VPWR VPWR _194_ sky130_fd_sc_hd__inv_2
Xinput2 div[10] VGND VGND VPWR VPWR net2 sky130_fd_sc_hd__clkbuf_1
XFILLER_0_23_196 VGND VGND VPWR VPWR sky130_fd_sc_hd__decap_6
XFILLER_0_14_152 VGND VGND VPWR VPWR sky130_fd_sc_hd__decap_8
XANTENNA_clkbuf_3_0__f_clk_A clknet_0_clk VGND VGND VPWR VPWR sky130_fd_sc_hd__diode_2
XFILLER_0_22_96 VPWR VGND VPWR VGND sky130_ef_sc_hd__decap_12
XFILLER_0_22_41 VGND VGND VPWR VPWR sky130_fd_sc_hd__fill_1
XFILLER_0_11_133 VGND VGND VPWR VPWR sky130_fd_sc_hd__fill_1
XFILLER_0_11_111 VGND VGND VPWR VPWR sky130_fd_sc_hd__fill_1
XFILLER_0_2_62 VGND VGND VPWR VPWR sky130_fd_sc_hd__fill_2
Xmax_cap42 _069_ VGND VGND VPWR VPWR net42 sky130_fd_sc_hd__buf_1
XTAP_TAPCELL_ROW_25_161 VGND VPWR sky130_fd_sc_hd__tapvpwrvgnd_1
XFILLER_0_23_9 VGND VGND VPWR VPWR sky130_fd_sc_hd__fill_1
XFILLER_0_33_62 VGND VGND VPWR VPWR sky130_fd_sc_hd__fill_2
XFILLER_0_0_166 VGND VGND VPWR VPWR sky130_fd_sc_hd__fill_2
X_392_ BRG.counter\[1\] BRG.counter\[0\] BRG.counter\[2\] VGND VGND VPWR VPWR _170_
+ sky130_fd_sc_hd__and3_1
X_461_ net94 _214_ _216_ net36 VGND VGND VPWR VPWR _022_ sky130_fd_sc_hd__a22o_1
X_530_ net30 _189_ VGND VGND VPWR VPWR _259_ sky130_fd_sc_hd__nor2_2
XFILLER_0_30_85 VGND VGND VPWR VPWR sky130_fd_sc_hd__decap_3
Xfanout46 net49 VGND VGND VPWR VPWR net46 sky130_fd_sc_hd__buf_2
X_375_ _152_ _153_ net7 net8 _125_ VGND VGND VPWR VPWR _155_ sky130_fd_sc_hd__a2111oi_1
XFILLER_0_25_30 VPWR VGND VPWR VGND sky130_ef_sc_hd__decap_12
X_444_ rxtop.pCheck.memory\[7\] rxtop.pCheck.memory\[6\] VGND VGND VPWR VPWR _207_
+ sky130_fd_sc_hd__xnor2_1
X_513_ _250_ VGND VGND VPWR VPWR _040_ sky130_fd_sc_hd__clkbuf_1
XFILLER_0_26_194 VGND VGND VPWR VPWR sky130_fd_sc_hd__fill_2
XFILLER_0_18_139 VGND VGND VPWR VPWR sky130_fd_sc_hd__fill_1
XFILLER_0_18_106 VPWR VGND VPWR VGND sky130_ef_sc_hd__decap_12
XFILLER_0_32_197 VGND VGND VPWR VPWR sky130_fd_sc_hd__decap_4
XFILLER_0_32_153 VGND VGND VPWR VPWR sky130_fd_sc_hd__decap_4
X_358_ net1 net4 net5 VGND VGND VPWR VPWR _138_ sky130_fd_sc_hd__or3_1
X_427_ _192_ VGND VGND VPWR VPWR _193_ sky130_fd_sc_hd__inv_2
XPHY_EDGE_ROW_27_Right_27 VGND VGND VPWR VPWR sky130_fd_sc_hd__decap_3
Xinput3 div[11] VGND VGND VPWR VPWR net3 sky130_fd_sc_hd__clkbuf_1
XFILLER_0_23_186 VGND VGND VPWR VPWR sky130_fd_sc_hd__decap_3
XFILLER_0_23_153 VGND VGND VPWR VPWR sky130_fd_sc_hd__decap_6
XPHY_EDGE_ROW_18_Right_18 VGND VGND VPWR VPWR sky130_fd_sc_hd__decap_3
X_289_ _076_ _070_ _079_ VGND VGND VPWR VPWR _080_ sky130_fd_sc_hd__o21ai_1
XFILLER_0_11_76 VGND VGND VPWR VPWR sky130_fd_sc_hd__decap_4
XFILLER_0_14_197 VGND VGND VPWR VPWR sky130_fd_sc_hd__decap_4
XFILLER_0_28_201 VGND VGND VPWR VPWR sky130_fd_sc_hd__fill_1
XTAP_TAPCELL_ROW_28_170 VGND VPWR sky130_fd_sc_hd__tapvpwrvgnd_1
XFILLER_0_11_178 VGND VGND VPWR VPWR sky130_fd_sc_hd__fill_1
XFILLER_0_11_167 VGND VGND VPWR VPWR sky130_fd_sc_hd__fill_1
XFILLER_0_7_117 VGND VGND VPWR VPWR sky130_fd_sc_hd__decap_4
XFILLER_0_2_85 VGND VGND VPWR VPWR sky130_fd_sc_hd__fill_1
XFILLER_0_6_161 VGND VGND VPWR VPWR sky130_fd_sc_hd__decap_8
Xmax_cap43 _063_ VGND VGND VPWR VPWR net43 sky130_fd_sc_hd__buf_1
XFILLER_0_33_85 VGND VGND VPWR VPWR sky130_fd_sc_hd__fill_2
XFILLER_0_33_41 VPWR VGND VPWR VGND sky130_ef_sc_hd__decap_12
XFILLER_0_3_153 VGND VGND VPWR VPWR sky130_fd_sc_hd__fill_2
XPHY_EDGE_ROW_0_Right_0 VGND VGND VPWR VPWR sky130_fd_sc_hd__decap_3
XFILLER_0_0_101 VGND VGND VPWR VPWR sky130_fd_sc_hd__decap_8
XFILLER_0_8_201 VGND VGND VPWR VPWR sky130_fd_sc_hd__fill_1
X_391_ _168_ _169_ VGND VGND VPWR VPWR _003_ sky130_fd_sc_hd__nor2_1
X_460_ net98 _214_ _216_ net97 VGND VGND VPWR VPWR _021_ sky130_fd_sc_hd__a22o_1
XFILLER_0_30_97 VGND VGND VPWR VPWR sky130_fd_sc_hd__decap_8
X_589_ clknet_3_0__leaf_clk net64 net45 VGND VGND VPWR VPWR txtop.serializer.memory\[0\]
+ sky130_fd_sc_hd__dfrtp_1
Xfanout47 net49 VGND VGND VPWR VPWR net47 sky130_fd_sc_hd__buf_2
XFILLER_0_12_3 VPWR VGND VPWR VGND sky130_ef_sc_hd__decap_12
X_374_ _152_ _153_ VGND VGND VPWR VPWR _154_ sky130_fd_sc_hd__and2_1
X_443_ _204_ _205_ VGND VGND VPWR VPWR _206_ sky130_fd_sc_hd__xnor2_1
X_512_ txtop.pCalc.memory\[0\] net18 _249_ VGND VGND VPWR VPWR _250_ sky130_fd_sc_hd__mux2_1
XFILLER_0_25_42 VPWR VGND VPWR VGND sky130_ef_sc_hd__decap_12
XFILLER_0_18_118 VGND VGND VPWR VPWR sky130_fd_sc_hd__decap_8
XFILLER_0_32_165 VGND VGND VPWR VPWR sky130_fd_sc_hd__decap_4
XFILLER_0_17_173 VGND VGND VPWR VPWR sky130_fd_sc_hd__fill_1
XFILLER_0_17_162 VGND VGND VPWR VPWR sky130_fd_sc_hd__decap_6
XFILLER_0_1_3 VGND VGND VPWR VPWR sky130_fd_sc_hd__decap_8
Xinput4 div[1] VGND VGND VPWR VPWR net4 sky130_fd_sc_hd__buf_1
X_357_ _132_ _133_ _136_ VGND VGND VPWR VPWR _137_ sky130_fd_sc_hd__mux2_1
XFILLER_0_23_110 VGND VGND VPWR VPWR sky130_fd_sc_hd__fill_2
XPHY_EDGE_ROW_23_Left_57 VGND VGND VPWR VPWR sky130_fd_sc_hd__decap_3
X_288_ net40 _078_ VGND VGND VPWR VPWR _079_ sky130_fd_sc_hd__nand2_1
X_426_ _066_ rxtop.fsm_rx.Current\[1\] rxtop.fsm_rx.Current\[0\] VGND VGND VPWR VPWR
+ _192_ sky130_fd_sc_hd__or3b_1
XTAP_TAPCELL_ROW_28_171 VGND VPWR sky130_fd_sc_hd__tapvpwrvgnd_1
X_409_ BRG.counter\[7\] BRG.counter\[8\] _178_ VGND VGND VPWR VPWR _181_ sky130_fd_sc_hd__and3_1
XFILLER_0_11_113 VPWR VGND VPWR VGND sky130_ef_sc_hd__decap_12
XFILLER_0_33_53 VGND VGND VPWR VPWR sky130_fd_sc_hd__fill_1
XPHY_EDGE_ROW_26_Left_60 VGND VGND VPWR VPWR sky130_fd_sc_hd__decap_3
XFILLER_0_17_54 VGND VGND VPWR VPWR sky130_fd_sc_hd__fill_2
XTAP_TAPCELL_ROW_16_130 VGND VPWR sky130_fd_sc_hd__tapvpwrvgnd_1
XPHY_EDGE_ROW_10_Left_44 VGND VGND VPWR VPWR sky130_fd_sc_hd__decap_3
XFILLER_0_0_113 VGND VGND VPWR VPWR sky130_fd_sc_hd__fill_2
X_390_ BRG.counter\[1\] net83 VGND VGND VPWR VPWR _169_ sky130_fd_sc_hd__xnor2_1
XFILLER_0_8_96 VGND VGND VPWR VPWR sky130_fd_sc_hd__fill_1
X_588_ clknet_3_4__leaf_clk _031_ net50 VGND VGND VPWR VPWR txtop.fsm_tx.Current\[2\]
+ sky130_fd_sc_hd__dfrtp_2
Xfanout48 net49 VGND VGND VPWR VPWR net48 sky130_fd_sc_hd__clkbuf_2
X_373_ BRG.counter\[6\] net9 VGND VGND VPWR VPWR _153_ sky130_fd_sc_hd__or2b_1
X_511_ _249_ net25 _236_ net58 VGND VGND VPWR VPWR _039_ sky130_fd_sc_hd__a22o_1
X_442_ rx_synchronizer.rx_out net14 VGND VGND VPWR VPWR _205_ sky130_fd_sc_hd__xnor2_1
XFILLER_0_26_141 VGND VGND VPWR VPWR sky130_fd_sc_hd__decap_8
XFILLER_0_25_54 VGND VGND VPWR VPWR sky130_fd_sc_hd__fill_2
Xinput5 div[2] VGND VGND VPWR VPWR net5 sky130_fd_sc_hd__buf_1
X_356_ BRG.counter\[4\] _134_ net44 _130_ VGND VGND VPWR VPWR _136_ sky130_fd_sc_hd__a22o_1
X_287_ _077_ txtop.fsm_tx.BAUD_COUNTER\[2\] txtop.fsm_tx.BAUD_COUNTER\[4\] VGND VGND
+ VPWR VPWR _078_ sky130_fd_sc_hd__or3b_1
XFILLER_0_11_23 VPWR VGND VPWR VGND sky130_ef_sc_hd__decap_12
X_425_ net13 net42 _189_ _190_ VGND VGND VPWR VPWR _191_ sky130_fd_sc_hd__a31o_1
XTAP_TAPCELL_ROW_28_172 VGND VPWR sky130_fd_sc_hd__tapvpwrvgnd_1
X_408_ _168_ _180_ VGND VGND VPWR VPWR _009_ sky130_fd_sc_hd__nor2_1
XFILLER_0_22_77 VGND VGND VPWR VPWR sky130_fd_sc_hd__decap_6
XFILLER_0_11_125 VGND VGND VPWR VPWR sky130_fd_sc_hd__decap_8
X_339_ txtop.pCalc.memory\[3\] txtop.pCalc.memory\[2\] VGND VGND VPWR VPWR _120_ sky130_fd_sc_hd__xnor2_1
XFILLER_0_6_141 VGND VGND VPWR VPWR sky130_fd_sc_hd__fill_1
XFILLER_0_17_77 VGND VGND VPWR VPWR sky130_fd_sc_hd__fill_2
XFILLER_0_3_144 VGND VGND VPWR VPWR sky130_fd_sc_hd__decap_4
XFILLER_0_28_76 VGND VGND VPWR VPWR sky130_fd_sc_hd__fill_1
XFILLER_0_0_169 VPWR VGND VPWR VGND sky130_ef_sc_hd__decap_12
XANTENNA_input19_A tx_in[1] VGND VGND VPWR VPWR sky130_fd_sc_hd__diode_2
XFILLER_0_14_23 VGND VGND VPWR VPWR sky130_fd_sc_hd__decap_4
X_587_ clknet_3_1__leaf_clk _030_ net46 VGND VGND VPWR VPWR txtop.fsm_tx.Current\[1\]
+ sky130_fd_sc_hd__dfrtp_2
XFILLER_0_30_55 VGND VGND VPWR VPWR sky130_fd_sc_hd__decap_6
XFILLER_0_30_11 VGND VGND VPWR VPWR sky130_fd_sc_hd__fill_1
XANTENNA_clkbuf_3_3__f_clk_A clknet_0_clk VGND VGND VPWR VPWR sky130_fd_sc_hd__diode_2
XFILLER_0_14_67 VGND VGND VPWR VPWR sky130_fd_sc_hd__decap_4
Xfanout49 net15 VGND VGND VPWR VPWR net49 sky130_fd_sc_hd__clkbuf_2
X_372_ BRG.counter\[7\] net10 VGND VGND VPWR VPWR _152_ sky130_fd_sc_hd__xnor2_1
X_441_ _202_ _203_ VGND VGND VPWR VPWR _204_ sky130_fd_sc_hd__xnor2_1
X_510_ net17 VGND VGND VPWR VPWR _249_ sky130_fd_sc_hd__buf_2
XFILLER_0_26_197 VGND VGND VPWR VPWR sky130_fd_sc_hd__decap_4
XFILLER_0_26_131 VGND VGND VPWR VPWR sky130_fd_sc_hd__decap_8
X_355_ net1 net4 net5 net6 VGND VGND VPWR VPWR _135_ sky130_fd_sc_hd__nor4_1
XFILLER_0_23_178 VGND VGND VPWR VPWR sky130_fd_sc_hd__decap_8
X_286_ txtop.fsm_tx.BAUD_COUNTER\[1\] txtop.fsm_tx.BAUD_COUNTER\[0\] txtop.fsm_tx.BAUD_COUNTER\[3\]
+ VGND VGND VPWR VPWR _077_ sky130_fd_sc_hd__or3_1
XFILLER_0_11_35 VGND VGND VPWR VPWR sky130_fd_sc_hd__fill_1
X_424_ _066_ rxtop.fsm_rx.Current\[1\] _068_ VGND VGND VPWR VPWR _190_ sky130_fd_sc_hd__nor3_1
Xinput6 div[3] VGND VGND VPWR VPWR net6 sky130_fd_sc_hd__buf_1
XPHY_EDGE_ROW_23_Right_23 VGND VGND VPWR VPWR sky130_fd_sc_hd__decap_3
Xclkbuf_3_3__f_clk clknet_0_clk VGND VGND VPWR VPWR clknet_3_3__leaf_clk sky130_fd_sc_hd__clkbuf_16
XPHY_EDGE_ROW_14_Right_14 VGND VGND VPWR VPWR sky130_fd_sc_hd__decap_3
XPHY_EDGE_ROW_32_Right_32 VGND VGND VPWR VPWR sky130_fd_sc_hd__decap_3
X_407_ net115 _178_ VGND VGND VPWR VPWR _180_ sky130_fd_sc_hd__xnor2_1
XFILLER_0_22_67 VGND VGND VPWR VPWR sky130_fd_sc_hd__decap_3
XTAP_TAPCELL_ROW_19_140 VGND VPWR sky130_fd_sc_hd__tapvpwrvgnd_1
X_338_ _117_ _118_ VGND VGND VPWR VPWR _119_ sky130_fd_sc_hd__xnor2_1
X_269_ _061_ rxtop.fsm_rx.BAUD_COUNTER\[3\] _062_ VGND VGND VPWR VPWR _063_ sky130_fd_sc_hd__nor3_1
XFILLER_0_6_175 VGND VGND VPWR VPWR sky130_fd_sc_hd__fill_1
XFILLER_0_33_77 VGND VGND VPWR VPWR sky130_fd_sc_hd__fill_1
XFILLER_0_17_89 VGND VGND VPWR VPWR sky130_fd_sc_hd__decap_3
Xinput20 tx_in[2] VGND VGND VPWR VPWR net20 sky130_fd_sc_hd__clkbuf_1
XFILLER_0_28_3 VPWR VGND VPWR VGND sky130_ef_sc_hd__decap_12
XFILLER_0_3_123 VPWR VGND VPWR VGND sky130_ef_sc_hd__decap_12
XFILLER_0_3_167 VGND VGND VPWR VPWR sky130_fd_sc_hd__fill_1
XPHY_EDGE_ROW_4_Right_4 VGND VGND VPWR VPWR sky130_fd_sc_hd__decap_3
XFILLER_0_30_78 VGND VGND VPWR VPWR sky130_fd_sc_hd__decap_6
XFILLER_0_14_46 VGND VGND VPWR VPWR sky130_fd_sc_hd__fill_1
X_586_ clknet_3_4__leaf_clk _029_ net52 VGND VGND VPWR VPWR txtop.fsm_tx.Current\[0\]
+ sky130_fd_sc_hd__dfrtp_2
X_371_ net2 _150_ VGND VGND VPWR VPWR _151_ sky130_fd_sc_hd__or2_1
X_440_ rxtop.pCheck.memory\[1\] rxtop.pCheck.memory\[0\] VGND VGND VPWR VPWR _203_
+ sky130_fd_sc_hd__xor2_1
X_569_ clknet_3_7__leaf_clk rxtop.fsm_rx.BAUD_COUNTER_Next\[2\] net55 VGND VGND VPWR
+ VPWR rxtop.fsm_rx.BAUD_COUNTER\[2\] sky130_fd_sc_hd__dfrtp_1
XFILLER_0_5_77 VGND VGND VPWR VPWR sky130_fd_sc_hd__fill_2
XFILLER_0_32_157 VGND VGND VPWR VPWR sky130_fd_sc_hd__fill_1
X_354_ net7 VGND VGND VPWR VPWR _134_ sky130_fd_sc_hd__inv_2
XFILLER_0_23_113 VGND VGND VPWR VPWR sky130_fd_sc_hd__decap_3
X_285_ txtop.fsm_tx.Current\[2\] VGND VGND VPWR VPWR _076_ sky130_fd_sc_hd__inv_2
X_423_ _092_ VGND VGND VPWR VPWR _189_ sky130_fd_sc_hd__inv_2
Xinput7 div[4] VGND VGND VPWR VPWR net7 sky130_fd_sc_hd__buf_1
XFILLER_0_20_138 VGND VGND VPWR VPWR sky130_fd_sc_hd__fill_2
X_406_ _167_ _178_ _179_ VGND VGND VPWR VPWR _008_ sky130_fd_sc_hd__nor3_1
X_337_ txtop.pCalc.memory\[5\] txtop.pCalc.memory\[4\] VGND VGND VPWR VPWR _118_ sky130_fd_sc_hd__xor2_1
X_268_ rxtop.fsm_rx.BAUD_COUNTER\[1\] rxtop.fsm_rx.BAUD_COUNTER\[0\] rxtop.fsm_rx.BAUD_COUNTER\[2\]
+ VGND VGND VPWR VPWR _062_ sky130_fd_sc_hd__or3_1
XFILLER_0_11_105 VGND VGND VPWR VPWR sky130_fd_sc_hd__decap_6
XFILLER_0_6_121 VGND VGND VPWR VPWR sky130_fd_sc_hd__fill_2
XFILLER_0_6_132 VGND VGND VPWR VPWR sky130_fd_sc_hd__decap_3
XFILLER_0_33_34 VGND VGND VPWR VPWR sky130_fd_sc_hd__fill_2
XFILLER_0_33_23 VGND VGND VPWR VPWR sky130_fd_sc_hd__decap_3
XFILLER_0_17_57 VPWR VGND VPWR VGND sky130_ef_sc_hd__decap_12
Xinput10 div[7] VGND VGND VPWR VPWR net10 sky130_fd_sc_hd__buf_1
Xinput21 tx_in[3] VGND VGND VPWR VPWR net21 sky130_fd_sc_hd__clkbuf_1
XFILLER_0_3_113 VGND VGND VPWR VPWR sky130_fd_sc_hd__decap_6
XFILLER_0_3_135 VGND VGND VPWR VPWR sky130_fd_sc_hd__fill_1
XFILLER_0_28_89 VPWR VGND VPWR VGND sky130_ef_sc_hd__decap_12
XFILLER_0_28_23 VGND VGND VPWR VPWR sky130_fd_sc_hd__decap_4
XPHY_EDGE_ROW_14_Left_48 VGND VGND VPWR VPWR sky130_fd_sc_hd__decap_3
XFILLER_0_12_200 VGND VGND VPWR VPWR sky130_fd_sc_hd__fill_2
XFILLER_0_0_149 VGND VGND VPWR VPWR sky130_fd_sc_hd__fill_1
XFILLER_0_8_88 VGND VGND VPWR VPWR sky130_fd_sc_hd__fill_2
XTAP_TAPCELL_ROW_10_106 VGND VPWR sky130_fd_sc_hd__tapvpwrvgnd_1
XFILLER_0_30_35 VGND VGND VPWR VPWR sky130_fd_sc_hd__decap_3
XANTENNA_input24_A tx_in[6] VGND VGND VPWR VPWR sky130_fd_sc_hd__diode_2
X_585_ clknet_3_4__leaf_clk net16 net50 VGND VGND VPWR VPWR rx_synchronizer.sync_stage1
+ sky130_fd_sc_hd__dfstp_1
X_370_ net11 net12 _125_ _126_ VGND VGND VPWR VPWR _150_ sky130_fd_sc_hd__or4_1
XFILLER_0_25_57 VPWR VGND VPWR VGND sky130_ef_sc_hd__decap_12
X_568_ clknet_3_6__leaf_clk rxtop.fsm_rx.BAUD_COUNTER_Next\[1\] net55 VGND VGND VPWR
+ VPWR rxtop.fsm_rx.BAUD_COUNTER\[1\] sky130_fd_sc_hd__dfrtp_1
X_499_ _242_ net106 _236_ VGND VGND VPWR VPWR _243_ sky130_fd_sc_hd__mux2_1
XFILLER_0_32_169 VGND VGND VPWR VPWR sky130_fd_sc_hd__fill_1
XFILLER_0_32_125 VPWR VGND VPWR VGND sky130_ef_sc_hd__decap_12
X_353_ _130_ _131_ _125_ VGND VGND VPWR VPWR _133_ sky130_fd_sc_hd__a21o_1
X_284_ _071_ _072_ _073_ _074_ VGND VGND VPWR VPWR _075_ sky130_fd_sc_hd__and4bb_2
XPHY_EDGE_ROW_17_Left_51 VGND VGND VPWR VPWR sky130_fd_sc_hd__decap_3
X_422_ _188_ VGND VGND VPWR VPWR net41 sky130_fd_sc_hd__inv_2
Xinput8 div[5] VGND VGND VPWR VPWR net8 sky130_fd_sc_hd__buf_1
XFILLER_0_23_169 VGND VGND VPWR VPWR sky130_fd_sc_hd__fill_1
XPHY_EDGE_ROW_2_Left_36 VGND VGND VPWR VPWR sky130_fd_sc_hd__decap_3
XFILLER_0_9_174 VGND VGND VPWR VPWR sky130_fd_sc_hd__decap_4
X_405_ BRG.counter\[6\] _176_ VGND VGND VPWR VPWR _179_ sky130_fd_sc_hd__nor2_1
X_336_ txtop.pCalc.memory\[7\] txtop.pCalc.memory\[6\] VGND VGND VPWR VPWR _117_ sky130_fd_sc_hd__xnor2_1
X_267_ net114 VGND VGND VPWR VPWR _061_ sky130_fd_sc_hd__inv_2
XFILLER_0_17_69 VGND VGND VPWR VPWR sky130_fd_sc_hd__decap_8
XFILLER_0_33_57 VGND VGND VPWR VPWR sky130_fd_sc_hd__fill_2
Xinput11 div[8] VGND VGND VPWR VPWR net11 sky130_fd_sc_hd__clkbuf_1
X_319_ rxtop.fsm_rx.BAUD_COUNTER\[1\] rxtop.fsm_rx.BAUD_COUNTER\[0\] _075_ VGND VGND
+ VPWR VPWR _104_ sky130_fd_sc_hd__and3_1
Xinput22 tx_in[4] VGND VGND VPWR VPWR net22 sky130_fd_sc_hd__clkbuf_1
XFILLER_0_30_201 VGND VGND VPWR VPWR sky130_fd_sc_hd__fill_1
XTAP_TAPCELL_ROW_22_148 VGND VPWR sky130_fd_sc_hd__tapvpwrvgnd_1
XFILLER_0_21_201 VGND VGND VPWR VPWR sky130_fd_sc_hd__fill_1
XFILLER_0_33_3 VPWR VGND VPWR VGND sky130_ef_sc_hd__decap_12
XTAP_TAPCELL_ROW_10_107 VGND VPWR sky130_fd_sc_hd__tapvpwrvgnd_1
XFILLER_0_8_23 VGND VGND VPWR VPWR sky130_fd_sc_hd__decap_4
XPHY_EDGE_ROW_31_Left_65 VGND VGND VPWR VPWR sky130_fd_sc_hd__decap_3
X_584_ clknet_3_4__leaf_clk net57 net50 VGND VGND VPWR VPWR rx_synchronizer.rx_out
+ sky130_fd_sc_hd__dfstp_1
XANTENNA_input17_A tx_data_valid VGND VGND VPWR VPWR sky130_fd_sc_hd__diode_2
XTAP_TAPCELL_ROW_4_85 VGND VPWR sky130_fd_sc_hd__tapvpwrvgnd_1
XANTENNA_input9_A div[6] VGND VGND VPWR VPWR sky130_fd_sc_hd__diode_2
XFILLER_0_26_167 VGND VGND VPWR VPWR sky130_fd_sc_hd__decap_3
XFILLER_0_26_101 VGND VGND VPWR VPWR sky130_fd_sc_hd__fill_1
XFILLER_0_25_69 VPWR VGND VPWR VGND sky130_ef_sc_hd__decap_12
X_567_ clknet_3_6__leaf_clk rxtop.fsm_rx.BAUD_COUNTER_Next\[0\] net55 VGND VGND VPWR
+ VPWR rxtop.fsm_rx.BAUD_COUNTER\[0\] sky130_fd_sc_hd__dfrtp_1
XFILLER_0_1_201 VGND VGND VPWR VPWR sky130_fd_sc_hd__fill_1
X_498_ txtop.serializer.memory\[3\] net20 net17 VGND VGND VPWR VPWR _242_ sky130_fd_sc_hd__mux2_1
XFILLER_0_32_137 VGND VGND VPWR VPWR sky130_fd_sc_hd__decap_3
XFILLER_0_32_115 VGND VGND VPWR VPWR sky130_fd_sc_hd__fill_1
XFILLER_0_17_145 VGND VGND VPWR VPWR sky130_fd_sc_hd__decap_3
X_421_ _076_ txtop.fsm_tx.Current\[1\] txtop.fsm_tx.Current\[0\] _078_ VGND VGND VPWR
+ VPWR _188_ sky130_fd_sc_hd__or4_1
Xinput9 div[6] VGND VGND VPWR VPWR net9 sky130_fd_sc_hd__buf_1
X_352_ _130_ _131_ VGND VGND VPWR VPWR _132_ sky130_fd_sc_hd__nand2_1
X_283_ BRG.counter\[1\] BRG.counter\[3\] VGND VGND VPWR VPWR _074_ sky130_fd_sc_hd__nor2_1
XFILLER_0_23_159 VGND VGND VPWR VPWR sky130_fd_sc_hd__fill_1
XTAP_TAPCELL_ROW_1_75 VGND VPWR sky130_fd_sc_hd__tapvpwrvgnd_1
X_619_ clknet_3_1__leaf_clk _057_ net49 VGND VGND VPWR VPWR txtop.serializer.ptr\[0\]
+ sky130_fd_sc_hd__dfrtp_1
XFILLER_0_9_142 VGND VGND VPWR VPWR sky130_fd_sc_hd__fill_2
XFILLER_0_9_153 VPWR VGND VPWR VGND sky130_ef_sc_hd__decap_12
X_404_ BRG.counter\[5\] BRG.counter\[4\] BRG.counter\[6\] _173_ VGND VGND VPWR VPWR
+ _178_ sky130_fd_sc_hd__and4_1
XFILLER_0_22_15 VPWR VGND VPWR VGND sky130_ef_sc_hd__decap_12
X_335_ net14 _115_ VGND VGND VPWR VPWR _116_ sky130_fd_sc_hd__xnor2_1
XPHY_EDGE_ROW_10_Right_10 VGND VGND VPWR VPWR sky130_fd_sc_hd__decap_3
XTAP_TAPCELL_ROW_33_190 VGND VPWR sky130_fd_sc_hd__tapvpwrvgnd_1
XFILLER_0_33_69 VGND VGND VPWR VPWR sky130_fd_sc_hd__decap_8
Xinput12 div[9] VGND VGND VPWR VPWR net12 sky130_fd_sc_hd__buf_1
XANTENNA_clkbuf_3_6__f_clk_A clknet_0_clk VGND VGND VPWR VPWR sky130_fd_sc_hd__diode_2
X_318_ rxtop.fsm_rx.BAUD_COUNTER\[0\] _075_ rxtop.fsm_rx.BAUD_COUNTER\[1\] VGND VGND
+ VPWR VPWR _103_ sky130_fd_sc_hd__a21o_1
Xinput23 tx_in[5] VGND VGND VPWR VPWR net23 sky130_fd_sc_hd__clkbuf_1
XFILLER_0_3_148 VGND VGND VPWR VPWR sky130_fd_sc_hd__fill_1
XTAP_TAPCELL_ROW_7_96 VGND VPWR sky130_fd_sc_hd__tapvpwrvgnd_1
XTAP_TAPCELL_ROW_22_149 VGND VPWR sky130_fd_sc_hd__tapvpwrvgnd_1
XFILLER_0_0_118 VGND VGND VPWR VPWR sky130_fd_sc_hd__fill_2
X_583_ clknet_3_2__leaf_clk _002_ net47 VGND VGND VPWR VPWR BRG.counter\[11\] sky130_fd_sc_hd__dfrtp_1
XFILLER_0_14_27 VGND VGND VPWR VPWR sky130_fd_sc_hd__fill_1
XTAP_TAPCELL_ROW_10_108 VGND VPWR sky130_fd_sc_hd__tapvpwrvgnd_1
Xhold1 rx_synchronizer.sync_stage1 VGND VGND VPWR VPWR net57 sky130_fd_sc_hd__dlygate4sd3_1
XTAP_TAPCELL_ROW_4_86 VGND VPWR sky130_fd_sc_hd__tapvpwrvgnd_1
XPHY_EDGE_ROW_8_Right_8 VGND VGND VPWR VPWR sky130_fd_sc_hd__decap_3
X_566_ clknet_3_5__leaf_clk _028_ net51 VGND VGND VPWR VPWR rxtop.deserializer.ptr\[3\]
+ sky130_fd_sc_hd__dfrtp_1
XFILLER_0_5_69 VGND VGND VPWR VPWR sky130_fd_sc_hd__decap_8
X_497_ _241_ VGND VGND VPWR VPWR _033_ sky130_fd_sc_hd__clkbuf_1
XFILLER_0_32_105 VGND VGND VPWR VPWR sky130_fd_sc_hd__decap_4
XFILLER_0_10_6 VGND VGND VPWR VPWR sky130_fd_sc_hd__decap_3
X_351_ BRG.counter\[4\] net7 VGND VGND VPWR VPWR _131_ sky130_fd_sc_hd__or2b_1
X_282_ BRG.counter\[2\] BRG.counter\[0\] VGND VGND VPWR VPWR _073_ sky130_fd_sc_hd__and2b_1
XFILLER_0_16_190 VGND VGND VPWR VPWR sky130_fd_sc_hd__decap_6
X_420_ rx_synchronizer.rx_out _065_ VGND VGND VPWR VPWR net26 sky130_fd_sc_hd__nor2_1
XTAP_TAPCELL_ROW_1_76 VGND VPWR sky130_fd_sc_hd__tapvpwrvgnd_1
X_618_ clknet_3_3__leaf_clk txtop.fsm_tx.BAUD_COUNTER_Next\[4\] net46 VGND VGND VPWR
+ VPWR txtop.fsm_tx.BAUD_COUNTER\[4\] sky130_fd_sc_hd__dfrtp_1
XFILLER_0_14_116 VPWR VGND VPWR VGND sky130_ef_sc_hd__decap_12
X_549_ net93 _266_ VGND VGND VPWR VPWR _060_ sky130_fd_sc_hd__nor2_1
X_403_ _168_ _176_ _177_ VGND VGND VPWR VPWR _007_ sky130_fd_sc_hd__nor3_1
XFILLER_0_22_27 VGND VGND VPWR VPWR sky130_fd_sc_hd__fill_1
XFILLER_0_13_193 VGND VGND VPWR VPWR sky130_fd_sc_hd__fill_1
X_334_ txtop.pCalc.memory\[1\] txtop.pCalc.memory\[0\] VGND VGND VPWR VPWR _115_ sky130_fd_sc_hd__xnor2_1
XFILLER_0_9_121 VGND VGND VPWR VPWR sky130_fd_sc_hd__fill_1
XFILLER_0_9_165 VGND VGND VPWR VPWR sky130_fd_sc_hd__decap_3
XFILLER_0_2_15 VGND VGND VPWR VPWR sky130_fd_sc_hd__fill_1
XTAP_TAPCELL_ROW_33_191 VGND VPWR sky130_fd_sc_hd__tapvpwrvgnd_1
XFILLER_0_12_93 VGND VGND VPWR VPWR sky130_fd_sc_hd__fill_1
XFILLER_0_33_15 VGND VGND VPWR VPWR sky130_fd_sc_hd__decap_8
Xinput24 tx_in[6] VGND VGND VPWR VPWR net24 sky130_fd_sc_hd__clkbuf_1
X_317_ _066_ _068_ _093_ VGND VGND VPWR VPWR _102_ sky130_fd_sc_hd__or3_1
Xinput13 parityEnable VGND VGND VPWR VPWR net13 sky130_fd_sc_hd__dlymetal6s2s_1
XTAP_TAPCELL_ROW_7_97 VGND VPWR sky130_fd_sc_hd__tapvpwrvgnd_1
XFILLER_0_28_48 VPWR VGND VPWR VGND sky130_ef_sc_hd__decap_12
XFILLER_0_28_37 VGND VGND VPWR VPWR sky130_fd_sc_hd__decap_8
XFILLER_0_28_15 VGND VGND VPWR VPWR sky130_fd_sc_hd__decap_4
XTAP_TAPCELL_ROW_13_117 VGND VPWR sky130_fd_sc_hd__tapvpwrvgnd_1
XFILLER_0_18_81 VGND VGND VPWR VPWR sky130_fd_sc_hd__decap_3
X_582_ clknet_3_2__leaf_clk _001_ net47 VGND VGND VPWR VPWR BRG.counter\[10\] sky130_fd_sc_hd__dfrtp_2
XTAP_TAPCELL_ROW_10_109 VGND VPWR sky130_fd_sc_hd__tapvpwrvgnd_1
XFILLER_0_30_27 VGND VGND VPWR VPWR sky130_fd_sc_hd__fill_1
XFILLER_0_29_177 VGND VGND VPWR VPWR sky130_fd_sc_hd__decap_3
XFILLER_0_29_100 VPWR VGND VPWR VGND sky130_ef_sc_hd__decap_12
Xhold2 txtop.serializer.memory\[7\] VGND VGND VPWR VPWR net58 sky130_fd_sc_hd__dlygate4sd3_1
XTAP_TAPCELL_ROW_4_87 VGND VPWR sky130_fd_sc_hd__tapvpwrvgnd_1
XFILLER_0_20_93 VGND VGND VPWR VPWR sky130_fd_sc_hd__fill_1
XFILLER_0_4_200 VGND VGND VPWR VPWR sky130_fd_sc_hd__fill_2
XANTENNA_input22_A tx_in[4] VGND VGND VPWR VPWR sky130_fd_sc_hd__diode_2
X_565_ clknet_3_5__leaf_clk _027_ net51 VGND VGND VPWR VPWR rxtop.deserializer.ptr\[2\]
+ sky130_fd_sc_hd__dfrtp_1
X_496_ _240_ net111 _236_ VGND VGND VPWR VPWR _241_ sky130_fd_sc_hd__mux2_1
XFILLER_0_17_169 VGND VGND VPWR VPWR sky130_fd_sc_hd__decap_4
X_350_ BRG.counter\[5\] net8 VGND VGND VPWR VPWR _130_ sky130_fd_sc_hd__xnor2_1
X_281_ BRG.counter\[5\] BRG.counter\[4\] BRG.counter\[7\] BRG.counter\[6\] VGND VGND
+ VPWR VPWR _072_ sky130_fd_sc_hd__or4_1
XFILLER_0_23_106 VGND VGND VPWR VPWR sky130_fd_sc_hd__fill_1
XTAP_TAPCELL_ROW_1_77 VGND VPWR sky130_fd_sc_hd__tapvpwrvgnd_1
X_617_ clknet_3_3__leaf_clk txtop.fsm_tx.BAUD_COUNTER_Next\[3\] net48 VGND VGND VPWR
+ VPWR txtop.fsm_tx.BAUD_COUNTER\[3\] sky130_fd_sc_hd__dfrtp_1
X_548_ net120 net92 _263_ _249_ VGND VGND VPWR VPWR _266_ sky130_fd_sc_hd__a31o_1
X_479_ _124_ _227_ VGND VGND VPWR VPWR _228_ sky130_fd_sc_hd__or2b_1
XFILLER_0_26_70 VGND VGND VPWR VPWR sky130_fd_sc_hd__decap_8
XFILLER_0_20_109 VPWR VGND VPWR VGND sky130_ef_sc_hd__decap_12
X_402_ BRG.counter\[4\] _173_ BRG.counter\[5\] VGND VGND VPWR VPWR _177_ sky130_fd_sc_hd__a21oi_1
XFILLER_0_2_27 VGND VGND VPWR VPWR sky130_fd_sc_hd__fill_1
X_333_ txtop.fsm_tx.Current\[0\] VGND VGND VPWR VPWR _114_ sky130_fd_sc_hd__inv_2
XTAP_TAPCELL_ROW_25_159 VGND VPWR sky130_fd_sc_hd__tapvpwrvgnd_1
XFILLER_0_10_197 VGND VGND VPWR VPWR sky130_fd_sc_hd__fill_1
XFILLER_0_6_169 VGND VGND VPWR VPWR sky130_fd_sc_hd__fill_2
XFILLER_0_33_201 VGND VGND VPWR VPWR sky130_fd_sc_hd__fill_1
XTAP_TAPCELL_ROW_33_192 VGND VPWR sky130_fd_sc_hd__tapvpwrvgnd_1
Xinput25 tx_in[7] VGND VGND VPWR VPWR net25 sky130_fd_sc_hd__buf_1
X_316_ net101 _075_ _101_ VGND VGND VPWR VPWR rxtop.fsm_rx.BAUD_COUNTER_Next\[0\]
+ sky130_fd_sc_hd__o21a_1
Xinput14 parityType VGND VGND VPWR VPWR net14 sky130_fd_sc_hd__buf_1
XTAP_TAPCELL_ROW_7_98 VGND VPWR sky130_fd_sc_hd__tapvpwrvgnd_1
XTAP_TAPCELL_ROW_13_118 VGND VPWR sky130_fd_sc_hd__tapvpwrvgnd_1
XFILLER_0_0_109 VGND VGND VPWR VPWR sky130_fd_sc_hd__fill_1
XFILLER_0_28_27 VGND VGND VPWR VPWR sky130_fd_sc_hd__fill_1
XFILLER_0_18_93 VGND VGND VPWR VPWR sky130_fd_sc_hd__decap_3
X_581_ clknet_3_2__leaf_clk _011_ net47 VGND VGND VPWR VPWR BRG.counter\[9\] sky130_fd_sc_hd__dfrtp_1
Xhold3 _038_ VGND VGND VPWR VPWR net59 sky130_fd_sc_hd__dlygate4sd3_1
XFILLER_0_14_29 VGND VGND VPWR VPWR sky130_fd_sc_hd__fill_1
XTAP_TAPCELL_ROW_4_88 VGND VPWR sky130_fd_sc_hd__tapvpwrvgnd_1
XPHY_EDGE_ROW_9_Left_43 VGND VGND VPWR VPWR sky130_fd_sc_hd__decap_3
XFILLER_0_29_167 VGND VGND VPWR VPWR sky130_fd_sc_hd__fill_1
XFILLER_0_29_145 VGND VGND VPWR VPWR sky130_fd_sc_hd__fill_2
XANTENNA_input15_A rst VGND VGND VPWR VPWR sky130_fd_sc_hd__diode_2
X_495_ txtop.serializer.memory\[2\] net19 net17 VGND VGND VPWR VPWR _240_ sky130_fd_sc_hd__mux2_1
X_564_ clknet_3_5__leaf_clk _026_ net51 VGND VGND VPWR VPWR rxtop.deserializer.ptr\[1\]
+ sky130_fd_sc_hd__dfrtp_1
XANTENNA_input7_A div[4] VGND VGND VPWR VPWR sky130_fd_sc_hd__diode_2
X_280_ BRG.counter\[9\] BRG.counter\[8\] BRG.counter\[11\] BRG.counter\[10\] VGND
+ VGND VPWR VPWR _071_ sky130_fd_sc_hd__or4_1
XFILLER_0_16_170 VGND VGND VPWR VPWR sky130_fd_sc_hd__fill_1
X_616_ clknet_3_1__leaf_clk txtop.fsm_tx.BAUD_COUNTER_Next\[2\] net52 VGND VGND VPWR
+ VPWR txtop.fsm_tx.BAUD_COUNTER\[2\] sky130_fd_sc_hd__dfrtp_1
X_478_ txtop.serializer.ptr\[1\] txtop.serializer.ptr\[0\] txtop.serializer.ptr\[2\]
+ txtop.serializer.ptr\[3\] VGND VGND VPWR VPWR _227_ sky130_fd_sc_hd__or4b_1
X_547_ txtop.serializer.ptr\[2\] _263_ net92 VGND VGND VPWR VPWR _265_ sky130_fd_sc_hd__a21oi_1
XFILLER_0_13_173 VPWR VGND VPWR VGND sky130_ef_sc_hd__decap_12
X_401_ BRG.counter\[5\] BRG.counter\[4\] _173_ VGND VGND VPWR VPWR _176_ sky130_fd_sc_hd__and3_1
XFILLER_0_22_29 VPWR VGND VPWR VGND sky130_ef_sc_hd__decap_12
XPHY_EDGE_ROW_22_Left_56 VGND VGND VPWR VPWR sky130_fd_sc_hd__decap_3
X_332_ _096_ _099_ _112_ _113_ VGND VGND VPWR VPWR rxtop.fsm_rx.BAUD_COUNTER_Next\[4\]
+ sky130_fd_sc_hd__o211a_1
XTAP_TAPCELL_ROW_33_193 VGND VPWR sky130_fd_sc_hd__tapvpwrvgnd_1
XTAP_TAPCELL_ROW_16_127 VGND VPWR sky130_fd_sc_hd__tapvpwrvgnd_1
X_315_ rxtop.fsm_rx.BAUD_COUNTER\[0\] _075_ _096_ _100_ VGND VGND VPWR VPWR _101_
+ sky130_fd_sc_hd__o2bb2a_1
Xinput15 rst VGND VGND VPWR VPWR net15 sky130_fd_sc_hd__buf_1
XTAP_TAPCELL_ROW_13_119 VGND VPWR sky130_fd_sc_hd__tapvpwrvgnd_1
XFILLER_0_8_27 VGND VGND VPWR VPWR sky130_fd_sc_hd__fill_1
Xclkbuf_3_4__f_clk clknet_0_clk VGND VGND VPWR VPWR clknet_3_4__leaf_clk sky130_fd_sc_hd__clkbuf_16
XFILLER_0_26_6 VGND VGND VPWR VPWR sky130_fd_sc_hd__fill_2
X_580_ clknet_3_3__leaf_clk _010_ net47 VGND VGND VPWR VPWR BRG.counter\[8\] sky130_fd_sc_hd__dfrtp_1
Xhold4 net28 VGND VGND VPWR VPWR net60 sky130_fd_sc_hd__dlygate4sd3_1
XFILLER_0_29_113 VPWR VGND VPWR VGND sky130_ef_sc_hd__decap_12
XFILLER_0_20_62 VGND VGND VPWR VPWR sky130_fd_sc_hd__fill_2
XPHY_EDGE_ROW_26_Right_26 VGND VGND VPWR VPWR sky130_fd_sc_hd__decap_3
XFILLER_0_25_18 VPWR VGND VPWR VGND sky130_ef_sc_hd__decap_12
XPHY_EDGE_ROW_17_Right_17 VGND VGND VPWR VPWR sky130_fd_sc_hd__decap_3
X_563_ clknet_3_5__leaf_clk _025_ net51 VGND VGND VPWR VPWR rxtop.deserializer.ptr\[0\]
+ sky130_fd_sc_hd__dfrtp_1
XFILLER_0_0_83 VGND VGND VPWR VPWR sky130_fd_sc_hd__fill_1
XFILLER_0_26_149 VGND VGND VPWR VPWR sky130_fd_sc_hd__decap_3
X_494_ net63 _236_ _237_ txtop.serializer.memory\[1\] _239_ VGND VGND VPWR VPWR _032_
+ sky130_fd_sc_hd__a221o_1
X_615_ clknet_3_6__leaf_clk txtop.fsm_tx.BAUD_COUNTER_Next\[1\] net55 VGND VGND VPWR
+ VPWR txtop.fsm_tx.BAUD_COUNTER\[1\] sky130_fd_sc_hd__dfrtp_1
X_546_ net104 _263_ _264_ VGND VGND VPWR VPWR _059_ sky130_fd_sc_hd__o21a_1
X_477_ net13 VGND VGND VPWR VPWR _226_ sky130_fd_sc_hd__inv_2
XFILLER_0_13_185 VGND VGND VPWR VPWR sky130_fd_sc_hd__fill_1
XFILLER_0_13_152 VGND VGND VPWR VPWR sky130_fd_sc_hd__decap_8
XTAP_TAPCELL_ROW_28_169 VGND VPWR sky130_fd_sc_hd__tapvpwrvgnd_1
X_400_ _168_ _175_ VGND VGND VPWR VPWR _006_ sky130_fd_sc_hd__nor2_1
X_331_ _061_ _111_ VGND VGND VPWR VPWR _113_ sky130_fd_sc_hd__or2_1
XFILLER_0_6_82 VGND VGND VPWR VPWR sky130_fd_sc_hd__fill_2
X_529_ _258_ VGND VGND VPWR VPWR _048_ sky130_fd_sc_hd__clkbuf_1
XFILLER_0_33_29 VGND VGND VPWR VPWR sky130_fd_sc_hd__fill_2
XTAP_TAPCELL_ROW_16_128 VGND VPWR sky130_fd_sc_hd__tapvpwrvgnd_1
X_314_ _066_ _098_ _099_ VGND VGND VPWR VPWR _100_ sky130_fd_sc_hd__o21a_1
Xinput16 rx VGND VGND VPWR VPWR net16 sky130_fd_sc_hd__clkbuf_1
XFILLER_0_3_119 VGND VGND VPWR VPWR sky130_fd_sc_hd__fill_1
XFILLER_0_2_185 VGND VGND VPWR VPWR sky130_fd_sc_hd__decap_3
XFILLER_0_19_6 VGND VGND VPWR VPWR sky130_fd_sc_hd__fill_2
XFILLER_0_30_19 VGND VGND VPWR VPWR sky130_fd_sc_hd__decap_8
XFILLER_0_29_125 VPWR VGND VPWR VGND sky130_ef_sc_hd__decap_12
Xhold5 txtop.serializer.memory\[6\] VGND VGND VPWR VPWR net61 sky130_fd_sc_hd__dlygate4sd3_1
XFILLER_0_26_139 VGND VGND VPWR VPWR sky130_fd_sc_hd__fill_1
X_562_ clknet_3_5__leaf_clk _024_ net51 VGND VGND VPWR VPWR net38 sky130_fd_sc_hd__dfrtp_1
X_493_ _238_ net18 VGND VGND VPWR VPWR _239_ sky130_fd_sc_hd__and2_1
XFILLER_0_32_109 VGND VGND VPWR VPWR sky130_fd_sc_hd__fill_1
XFILLER_0_15_63 VGND VGND VPWR VPWR sky130_fd_sc_hd__fill_1
X_614_ clknet_3_3__leaf_clk net109 net48 VGND VGND VPWR VPWR txtop.fsm_tx.BAUD_COUNTER\[0\]
+ sky130_fd_sc_hd__dfrtp_1
X_545_ net121 _263_ _249_ VGND VGND VPWR VPWR _264_ sky130_fd_sc_hd__a21oi_1
XANTENNA_input20_A tx_in[2] VGND VGND VPWR VPWR sky130_fd_sc_hd__diode_2
X_476_ _225_ VGND VGND VPWR VPWR _028_ sky130_fd_sc_hd__clkbuf_1
XFILLER_0_6_3 VPWR VGND VPWR VGND sky130_ef_sc_hd__decap_12
XFILLER_0_22_197 VGND VGND VPWR VPWR sky130_fd_sc_hd__decap_4
XFILLER_0_9_169 VGND VGND VPWR VPWR sky130_fd_sc_hd__fill_2
X_330_ _061_ _111_ VGND VGND VPWR VPWR _112_ sky130_fd_sc_hd__nand2_1
XFILLER_0_6_61 VPWR VGND VPWR VGND sky130_ef_sc_hd__decap_12
X_459_ net97 _214_ _216_ net88 VGND VGND VPWR VPWR _020_ sky130_fd_sc_hd__a22o_1
XFILLER_0_12_97 VPWR VGND VPWR VGND sky130_ef_sc_hd__decap_12
XFILLER_0_12_64 VPWR VGND VPWR VGND sky130_ef_sc_hd__decap_12
XFILLER_0_10_134 VGND VGND VPWR VPWR sky130_fd_sc_hd__decap_3
XFILLER_0_2_19 VGND VGND VPWR VPWR sky130_fd_sc_hd__decap_8
X_528_ net103 net63 _237_ VGND VGND VPWR VPWR _258_ sky130_fd_sc_hd__mux2_1
XFILLER_0_10_178 VPWR VGND VPWR VGND sky130_ef_sc_hd__decap_12
XTAP_TAPCELL_ROW_16_129 VGND VPWR sky130_fd_sc_hd__tapvpwrvgnd_1
X_313_ rxtop.fsm_rx.Current\[1\] _068_ _094_ VGND VGND VPWR VPWR _099_ sky130_fd_sc_hd__o21ba_1
Xinput17 tx_data_valid VGND VGND VPWR VPWR net17 sky130_fd_sc_hd__buf_2
XFILLER_0_3_109 VGND VGND VPWR VPWR sky130_fd_sc_hd__decap_3
XTAP_TAPCELL_ROW_30_176 VGND VPWR sky130_fd_sc_hd__tapvpwrvgnd_1
XFILLER_0_23_41 VPWR VGND VPWR VGND sky130_ef_sc_hd__decap_12
XFILLER_0_2_164 VGND VGND VPWR VPWR sky130_fd_sc_hd__fill_1
XFILLER_0_8_29 VGND VGND VPWR VPWR sky130_fd_sc_hd__fill_1
XFILLER_0_29_137 VGND VGND VPWR VPWR sky130_fd_sc_hd__decap_8
Xhold6 _037_ VGND VGND VPWR VPWR net62 sky130_fd_sc_hd__dlygate4sd3_1
XFILLER_0_31_6 VGND VGND VPWR VPWR sky130_fd_sc_hd__fill_1
XFILLER_0_0_52 VGND VGND VPWR VPWR sky130_fd_sc_hd__decap_4
XPHY_EDGE_ROW_3_Right_3 VGND VGND VPWR VPWR sky130_fd_sc_hd__decap_3
XFILLER_0_9_50 VGND VGND VPWR VPWR sky130_fd_sc_hd__decap_6
XFILLER_0_9_94 VGND VGND VPWR VPWR sky130_fd_sc_hd__decap_4
X_561_ clknet_3_7__leaf_clk _023_ net53 VGND VGND VPWR VPWR net37 sky130_fd_sc_hd__dfrtp_1
X_492_ net17 VGND VGND VPWR VPWR _238_ sky130_fd_sc_hd__clkbuf_2
XFILLER_0_25_140 VPWR VGND VPWR VGND sky130_ef_sc_hd__decap_12
XTAP_TAPCELL_ROW_5_90 VGND VPWR sky130_fd_sc_hd__tapvpwrvgnd_1
XFILLER_0_31_198 VGND VGND VPWR VPWR sky130_fd_sc_hd__decap_4
X_613_ clknet_3_5__leaf_clk net85 net52 VGND VGND VPWR VPWR rxtop.pCheck.memory\[7\]
+ sky130_fd_sc_hd__dfrtp_1
XANTENNA_input13_A parityEnable VGND VGND VPWR VPWR sky130_fd_sc_hd__diode_2
XFILLER_0_26_41 VGND VGND VPWR VPWR sky130_fd_sc_hd__decap_8
X_544_ _249_ _262_ _263_ VGND VGND VPWR VPWR _058_ sky130_fd_sc_hd__nor3_1
X_475_ _224_ _223_ net116 VGND VGND VPWR VPWR _225_ sky130_fd_sc_hd__mux2_1
XANTENNA_input5_A div[2] VGND VGND VPWR VPWR sky130_fd_sc_hd__diode_2
XFILLER_0_6_73 VGND VGND VPWR VPWR sky130_fd_sc_hd__decap_4
X_458_ net88 _214_ _216_ net33 VGND VGND VPWR VPWR _019_ sky130_fd_sc_hd__a22o_1
X_389_ net83 _168_ VGND VGND VPWR VPWR _000_ sky130_fd_sc_hd__nor2_1
X_527_ _257_ VGND VGND VPWR VPWR _047_ sky130_fd_sc_hd__clkbuf_1
XTAP_TAPCELL_ROW_19_138 VGND VPWR sky130_fd_sc_hd__tapvpwrvgnd_1
XFILLER_0_12_76 VGND VGND VPWR VPWR sky130_fd_sc_hd__decap_8
XFILLER_0_12_54 VGND VGND VPWR VPWR sky130_fd_sc_hd__decap_3
XFILLER_0_12_43 VGND VGND VPWR VPWR sky130_fd_sc_hd__decap_4
XTAP_TAPCELL_ROW_2_80 VGND VPWR sky130_fd_sc_hd__tapvpwrvgnd_1
X_312_ rxtop.fsm_rx.BAUD_COUNTER\[4\] _097_ _062_ VGND VGND VPWR VPWR _098_ sky130_fd_sc_hd__or3_1
Xinput18 tx_in[0] VGND VGND VPWR VPWR net18 sky130_fd_sc_hd__clkbuf_1
XTAP_TAPCELL_ROW_30_177 VGND VPWR sky130_fd_sc_hd__tapvpwrvgnd_1
XFILLER_0_23_53 VGND VGND VPWR VPWR sky130_fd_sc_hd__decap_3
XFILLER_0_3_30 VPWR VGND VPWR VGND sky130_ef_sc_hd__decap_12
XFILLER_0_18_53 VGND VGND VPWR VPWR sky130_fd_sc_hd__decap_8
Xhold7 txtop.serializer.memory\[0\] VGND VGND VPWR VPWR net63 sky130_fd_sc_hd__dlygate4sd3_1
XFILLER_0_29_41 VPWR VGND VPWR VGND sky130_ef_sc_hd__decap_12
XPHY_EDGE_ROW_29_Left_63 VGND VGND VPWR VPWR sky130_fd_sc_hd__decap_3
XFILLER_0_28_193 VGND VGND VPWR VPWR sky130_fd_sc_hd__decap_3
XPHY_EDGE_ROW_13_Left_47 VGND VGND VPWR VPWR sky130_fd_sc_hd__decap_3
XFILLER_0_0_42 VGND VGND VPWR VPWR sky130_fd_sc_hd__decap_3
X_560_ clknet_3_6__leaf_clk net95 net53 VGND VGND VPWR VPWR net36 sky130_fd_sc_hd__dfrtp_1
X_491_ net17 _234_ VGND VGND VPWR VPWR _237_ sky130_fd_sc_hd__nor2b_2
XFILLER_0_31_31 VGND VGND VPWR VPWR sky130_fd_sc_hd__fill_1
XFILLER_0_25_152 VGND VGND VPWR VPWR sky130_fd_sc_hd__decap_6
XPHY_EDGE_ROW_22_Right_22 VGND VGND VPWR VPWR sky130_fd_sc_hd__decap_3
XPHY_EDGE_ROW_13_Right_13 VGND VGND VPWR VPWR sky130_fd_sc_hd__decap_3
XTAP_TAPCELL_ROW_5_91 VGND VPWR sky130_fd_sc_hd__tapvpwrvgnd_1
XPHY_EDGE_ROW_31_Right_31 VGND VGND VPWR VPWR sky130_fd_sc_hd__decap_3
XFILLER_0_22_3 VPWR VGND VPWR VGND sky130_ef_sc_hd__decap_12
XFILLER_0_16_141 VPWR VGND VPWR VGND sky130_ef_sc_hd__decap_12
XFILLER_0_16_130 VGND VGND VPWR VPWR sky130_fd_sc_hd__decap_8
X_612_ clknet_3_7__leaf_clk net78 net53 VGND VGND VPWR VPWR rxtop.pCheck.memory\[6\]
+ sky130_fd_sc_hd__dfrtp_1
X_543_ txtop.serializer.ptr\[1\] txtop.serializer.ptr\[0\] _234_ VGND VGND VPWR VPWR
+ _263_ sky130_fd_sc_hd__and3_1
X_474_ rxtop.deserializer.ptr\[1\] rxtop.deserializer.ptr\[0\] rxtop.deserializer.ptr\[2\]
+ _213_ VGND VGND VPWR VPWR _224_ sky130_fd_sc_hd__and4_1
XPHY_EDGE_ROW_16_Left_50 VGND VGND VPWR VPWR sky130_fd_sc_hd__decap_3
XFILLER_0_13_111 VGND VGND VPWR VPWR sky130_fd_sc_hd__fill_1
XTAP_TAPCELL_ROW_19_139 VGND VPWR sky130_fd_sc_hd__tapvpwrvgnd_1
X_526_ txtop.pCalc.memory\[7\] net25 _238_ VGND VGND VPWR VPWR _257_ sky130_fd_sc_hd__mux2_1
X_457_ net33 _214_ _216_ net99 VGND VGND VPWR VPWR _018_ sky130_fd_sc_hd__a22o_1
X_388_ _167_ VGND VGND VPWR VPWR _168_ sky130_fd_sc_hd__buf_2
XFILLER_0_12_33 VGND VGND VPWR VPWR sky130_fd_sc_hd__decap_6
XTAP_TAPCELL_ROW_2_81 VGND VPWR sky130_fd_sc_hd__tapvpwrvgnd_1
X_311_ rxtop.fsm_rx.BAUD_COUNTER\[3\] VGND VGND VPWR VPWR _097_ sky130_fd_sc_hd__inv_2
XPHY_EDGE_ROW_1_Left_35 VGND VGND VPWR VPWR sky130_fd_sc_hd__decap_3
Xinput19 tx_in[1] VGND VGND VPWR VPWR net19 sky130_fd_sc_hd__clkbuf_1
XTAP_TAPCELL_ROW_30_178 VGND VPWR sky130_fd_sc_hd__tapvpwrvgnd_1
X_509_ txtop.serializer.memory\[6\] _236_ _237_ net58 _248_ VGND VGND VPWR VPWR _038_
+ sky130_fd_sc_hd__a221o_1
XTAP_TAPCELL_ROW_21_145 VGND VPWR sky130_fd_sc_hd__tapvpwrvgnd_1
XANTENNA_clkbuf_3_2__f_clk_A clknet_0_clk VGND VGND VPWR VPWR sky130_fd_sc_hd__diode_2
XFILLER_0_3_42 VPWR VGND VPWR VGND sky130_ef_sc_hd__decap_12
Xhold8 _032_ VGND VGND VPWR VPWR net64 sky130_fd_sc_hd__dlygate4sd3_1
XFILLER_0_29_64 VPWR VGND VPWR VGND sky130_ef_sc_hd__decap_12
XFILLER_0_29_53 VGND VGND VPWR VPWR sky130_fd_sc_hd__decap_3
XFILLER_0_0_21 VGND VGND VPWR VPWR sky130_fd_sc_hd__fill_1
X_490_ _235_ VGND VGND VPWR VPWR _236_ sky130_fd_sc_hd__buf_2
XPHY_EDGE_ROW_30_Left_64 VGND VGND VPWR VPWR sky130_fd_sc_hd__decap_3
XFILLER_0_25_131 VGND VGND VPWR VPWR sky130_fd_sc_hd__fill_1
XFILLER_0_25_120 VGND VGND VPWR VPWR sky130_fd_sc_hd__fill_2
XFILLER_0_31_167 VGND VGND VPWR VPWR sky130_fd_sc_hd__fill_1
XFILLER_0_31_156 VGND VGND VPWR VPWR sky130_fd_sc_hd__decap_3
XFILLER_0_31_123 VGND VGND VPWR VPWR sky130_fd_sc_hd__decap_3
XFILLER_0_16_197 VGND VGND VPWR VPWR sky130_fd_sc_hd__decap_4
XFILLER_0_16_153 VGND VGND VPWR VPWR sky130_fd_sc_hd__decap_4
XFILLER_0_16_120 VGND VGND VPWR VPWR sky130_fd_sc_hd__fill_2
X_611_ clknet_3_7__leaf_clk net74 net53 VGND VGND VPWR VPWR rxtop.pCheck.memory\[5\]
+ sky130_fd_sc_hd__dfrtp_1
X_542_ txtop.serializer.ptr\[0\] _234_ net105 VGND VGND VPWR VPWR _262_ sky130_fd_sc_hd__a21oi_1
X_473_ net91 _221_ _223_ VGND VGND VPWR VPWR _027_ sky130_fd_sc_hd__o21a_1
XFILLER_0_26_21 VGND VGND VPWR VPWR sky130_fd_sc_hd__fill_1
XFILLER_0_26_10 VGND VGND VPWR VPWR sky130_fd_sc_hd__decap_6
XFILLER_0_13_167 VGND VGND VPWR VPWR sky130_fd_sc_hd__fill_1
XFILLER_0_9_106 VGND VGND VPWR VPWR sky130_fd_sc_hd__decap_4
X_456_ net32 _214_ _216_ net81 VGND VGND VPWR VPWR _017_ sky130_fd_sc_hd__a22o_1
X_387_ _166_ VGND VGND VPWR VPWR _167_ sky130_fd_sc_hd__buf_1
X_525_ _256_ VGND VGND VPWR VPWR _046_ sky130_fd_sc_hd__clkbuf_1
XFILLER_0_12_89 VGND VGND VPWR VPWR sky130_fd_sc_hd__decap_4
XFILLER_0_6_109 VPWR VGND VPWR VGND sky130_ef_sc_hd__decap_12
XTAP_TAPCELL_ROW_33_187 VGND VPWR sky130_fd_sc_hd__tapvpwrvgnd_1
X_310_ _093_ _095_ _063_ VGND VGND VPWR VPWR _096_ sky130_fd_sc_hd__o21ba_1
XFILLER_0_5_153 VPWR VGND VPWR VGND sky130_ef_sc_hd__decap_12
X_439_ rxtop.pCheck.memory\[3\] rxtop.pCheck.memory\[2\] VGND VGND VPWR VPWR _202_
+ sky130_fd_sc_hd__xor2_1
X_508_ _238_ net24 VGND VGND VPWR VPWR _248_ sky130_fd_sc_hd__and2_1
Xwire44 _135_ VGND VGND VPWR VPWR net44 sky130_fd_sc_hd__clkbuf_1
XTAP_TAPCELL_ROW_30_179 VGND VPWR sky130_fd_sc_hd__tapvpwrvgnd_1
XTAP_TAPCELL_ROW_21_146 VGND VPWR sky130_fd_sc_hd__tapvpwrvgnd_1
XFILLER_0_2_134 VGND VGND VPWR VPWR sky130_fd_sc_hd__decap_6
XFILLER_0_3_54 VGND VGND VPWR VPWR sky130_fd_sc_hd__fill_2
XTAP_TAPCELL_ROW_12_113 VGND VPWR sky130_fd_sc_hd__tapvpwrvgnd_1
XFILLER_0_18_11 VPWR VGND VPWR VGND sky130_ef_sc_hd__decap_12
Xhold9 net27 VGND VGND VPWR VPWR net65 sky130_fd_sc_hd__dlygate4sd3_1
XFILLER_0_29_76 VPWR VGND VPWR VGND sky130_ef_sc_hd__decap_12
XFILLER_0_0_77 VGND VGND VPWR VPWR sky130_fd_sc_hd__decap_6
XFILLER_0_31_44 VGND VGND VPWR VPWR sky130_fd_sc_hd__decap_3
XPHY_EDGE_ROW_7_Right_7 VGND VGND VPWR VPWR sky130_fd_sc_hd__decap_3
XFILLER_0_31_113 VGND VGND VPWR VPWR sky130_fd_sc_hd__fill_2
XFILLER_0_31_102 VGND VGND VPWR VPWR sky130_fd_sc_hd__decap_3
X_610_ clknet_3_7__leaf_clk net76 net53 VGND VGND VPWR VPWR rxtop.pCheck.memory\[4\]
+ sky130_fd_sc_hd__dfrtp_1
X_541_ _261_ VGND VGND VPWR VPWR _057_ sky130_fd_sc_hd__clkbuf_1
X_472_ net30 _213_ _222_ VGND VGND VPWR VPWR _223_ sky130_fd_sc_hd__o21ai_1
XFILLER_0_22_135 VGND VGND VPWR VPWR sky130_fd_sc_hd__decap_4
XANTENNA_input11_A div[8] VGND VGND VPWR VPWR sky130_fd_sc_hd__diode_2
X_386_ _148_ _160_ _163_ _165_ VGND VGND VPWR VPWR _166_ sky130_fd_sc_hd__and4b_1
X_524_ txtop.pCalc.memory\[6\] net24 _238_ VGND VGND VPWR VPWR _256_ sky130_fd_sc_hd__mux2_1
X_455_ _215_ VGND VGND VPWR VPWR _216_ sky130_fd_sc_hd__clkbuf_2
XTAP_TAPCELL_ROW_33_188 VGND VPWR sky130_fd_sc_hd__tapvpwrvgnd_1
XANTENNA_input3_A div[11] VGND VGND VPWR VPWR sky130_fd_sc_hd__diode_2
XFILLER_0_5_165 VGND VGND VPWR VPWR sky130_fd_sc_hd__decap_3
XFILLER_0_5_187 VGND VGND VPWR VPWR sky130_fd_sc_hd__decap_4
XTAP_TAPCELL_ROW_24_155 VGND VPWR sky130_fd_sc_hd__tapvpwrvgnd_1
X_369_ BRG.counter\[11\] net3 VGND VGND VPWR VPWR _149_ sky130_fd_sc_hd__xor2_1
X_507_ txtop.serializer.memory\[5\] _236_ _237_ net61 _247_ VGND VGND VPWR VPWR _037_
+ sky130_fd_sc_hd__a221o_1
X_438_ _067_ _195_ _196_ _201_ VGND VGND VPWR VPWR _014_ sky130_fd_sc_hd__o22ai_1
XTAP_TAPCELL_ROW_21_147 VGND VPWR sky130_fd_sc_hd__tapvpwrvgnd_1
XTAP_TAPCELL_ROW_12_114 VGND VPWR sky130_fd_sc_hd__tapvpwrvgnd_1
XFILLER_0_18_23 VGND VGND VPWR VPWR sky130_fd_sc_hd__decap_4
XFILLER_0_29_88 VPWR VGND VPWR VGND sky130_ef_sc_hd__decap_12
XFILLER_0_28_141 VGND VGND VPWR VPWR sky130_fd_sc_hd__decap_8
XFILLER_0_0_34 VGND VGND VPWR VPWR sky130_fd_sc_hd__fill_1
XFILLER_0_9_10 VGND VGND VPWR VPWR sky130_fd_sc_hd__fill_2
XFILLER_0_9_65 VGND VGND VPWR VPWR sky130_fd_sc_hd__fill_1
XFILLER_0_31_23 VGND VGND VPWR VPWR sky130_fd_sc_hd__fill_1
XFILLER_0_25_111 VGND VGND VPWR VPWR sky130_fd_sc_hd__fill_1
XFILLER_0_15_57 VGND VGND VPWR VPWR sky130_fd_sc_hd__decap_6
Xclkbuf_3_5__f_clk clknet_0_clk VGND VGND VPWR VPWR clknet_3_5__leaf_clk sky130_fd_sc_hd__clkbuf_16
XFILLER_0_31_169 VGND VGND VPWR VPWR sky130_fd_sc_hd__fill_1
XFILLER_0_16_166 VGND VGND VPWR VPWR sky130_fd_sc_hd__decap_4
XFILLER_0_16_111 VGND VGND VPWR VPWR sky130_fd_sc_hd__decap_3
X_471_ rxtop.deserializer.ptr\[1\] rxtop.deserializer.ptr\[0\] rxtop.deserializer.ptr\[2\]
+ _064_ VGND VGND VPWR VPWR _222_ sky130_fd_sc_hd__a31o_1
X_540_ _237_ _236_ txtop.serializer.ptr\[0\] VGND VGND VPWR VPWR _261_ sky130_fd_sc_hd__mux2_1
XFILLER_0_26_89 VPWR VGND VPWR VGND sky130_ef_sc_hd__decap_12
XFILLER_0_22_114 VGND VGND VPWR VPWR sky130_fd_sc_hd__fill_1
XFILLER_0_8_152 VPWR VGND VPWR VGND sky130_ef_sc_hd__decap_12
X_385_ BRG.counter\[10\] _164_ VGND VGND VPWR VPWR _165_ sky130_fd_sc_hd__xnor2_1
X_523_ _255_ VGND VGND VPWR VPWR _045_ sky130_fd_sc_hd__clkbuf_1
XFILLER_0_10_128 VGND VGND VPWR VPWR sky130_fd_sc_hd__fill_1
X_454_ net30 _213_ VGND VGND VPWR VPWR _215_ sky130_fd_sc_hd__nor2_1
XTAP_TAPCELL_ROW_33_189 VGND VPWR sky130_fd_sc_hd__tapvpwrvgnd_1
XTAP_TAPCELL_ROW_24_156 VGND VPWR sky130_fd_sc_hd__tapvpwrvgnd_1
X_368_ BRG.counter\[8\] _129_ _137_ _140_ _147_ VGND VGND VPWR VPWR _148_ sky130_fd_sc_hd__a2111o_1
XFILLER_0_23_57 VGND VGND VPWR VPWR sky130_fd_sc_hd__decap_3
X_506_ _238_ net23 VGND VGND VPWR VPWR _247_ sky130_fd_sc_hd__and2_1
X_299_ _076_ _070_ _086_ _087_ VGND VGND VPWR VPWR txtop.fsm_tx.BAUD_COUNTER_Next\[2\]
+ sky130_fd_sc_hd__a211oi_1
X_437_ _068_ _200_ _094_ VGND VGND VPWR VPWR _201_ sky130_fd_sc_hd__o21ai_1
XPHY_EDGE_ROW_29_Right_29 VGND VGND VPWR VPWR sky130_fd_sc_hd__decap_3
XPHY_EDGE_ROW_5_Left_39 VGND VGND VPWR VPWR sky130_fd_sc_hd__decap_3
XTAP_TAPCELL_ROW_12_115 VGND VPWR sky130_fd_sc_hd__tapvpwrvgnd_1
XFILLER_0_20_58 VGND VGND VPWR VPWR sky130_fd_sc_hd__fill_2
XFILLER_0_28_197 VGND VGND VPWR VPWR sky130_fd_sc_hd__decap_4
XFILLER_0_0_57 VPWR VGND VPWR VGND sky130_ef_sc_hd__decap_12
XFILLER_0_0_24 VGND VGND VPWR VPWR sky130_fd_sc_hd__fill_2
XFILLER_0_19_164 VGND VGND VPWR VPWR sky130_fd_sc_hd__decap_4
XPHY_EDGE_ROW_8_Left_42 VGND VGND VPWR VPWR sky130_fd_sc_hd__decap_3
XFILLER_0_31_57 VGND VGND VPWR VPWR sky130_fd_sc_hd__fill_2
XFILLER_0_25_167 VGND VGND VPWR VPWR sky130_fd_sc_hd__fill_1
XFILLER_0_31_148 VGND VGND VPWR VPWR sky130_fd_sc_hd__decap_8
XFILLER_0_15_6 VGND VGND VPWR VPWR sky130_fd_sc_hd__fill_2
X_599_ clknet_3_0__leaf_clk _042_ net45 VGND VGND VPWR VPWR txtop.pCalc.memory\[2\]
+ sky130_fd_sc_hd__dfrtp_1
X_470_ _215_ _220_ VGND VGND VPWR VPWR _221_ sky130_fd_sc_hd__nor2_1
XFILLER_0_13_3 VGND VGND VPWR VPWR sky130_fd_sc_hd__fill_2
X_384_ net2 _150_ VGND VGND VPWR VPWR _164_ sky130_fd_sc_hd__xnor2_1
X_522_ net118 net23 _238_ VGND VGND VPWR VPWR _255_ sky130_fd_sc_hd__mux2_1
X_453_ _213_ VGND VGND VPWR VPWR _214_ sky130_fd_sc_hd__clkbuf_2
XANTENNA_clkbuf_3_5__f_clk_A clknet_0_clk VGND VGND VPWR VPWR sky130_fd_sc_hd__diode_2
XFILLER_0_12_15 VPWR VGND VPWR VGND sky130_ef_sc_hd__decap_12
XFILLER_0_8_164 VGND VGND VPWR VPWR sky130_fd_sc_hd__decap_4
XFILLER_0_8_186 VGND VGND VPWR VPWR sky130_fd_sc_hd__fill_2
XFILLER_0_8_197 VGND VGND VPWR VPWR sky130_fd_sc_hd__decap_4
XFILLER_0_5_134 VPWR VGND VPWR VGND sky130_ef_sc_hd__decap_12
XTAP_TAPCELL_ROW_24_157 VGND VPWR sky130_fd_sc_hd__tapvpwrvgnd_1
XFILLER_0_2_3 VPWR VGND VPWR VGND sky130_ef_sc_hd__decap_12
X_367_ BRG.counter\[2\] _138_ _141_ _142_ _146_ VGND VGND VPWR VPWR _147_ sky130_fd_sc_hd__a311o_1
XPHY_EDGE_ROW_21_Left_55 VGND VGND VPWR VPWR sky130_fd_sc_hd__decap_3
X_298_ txtop.fsm_tx.BAUD_COUNTER\[2\] _083_ VGND VGND VPWR VPWR _087_ sky130_fd_sc_hd__and2_1
XTAP_TAPCELL_ROW_15_124 VGND VPWR sky130_fd_sc_hd__tapvpwrvgnd_1
X_505_ txtop.serializer.memory\[4\] _236_ _237_ net66 _246_ VGND VGND VPWR VPWR _036_
+ sky130_fd_sc_hd__a221o_1
X_436_ net13 _092_ VGND VGND VPWR VPWR _200_ sky130_fd_sc_hd__nor2_1
XFILLER_0_3_57 VPWR VGND VPWR VGND sky130_ef_sc_hd__decap_12
XTAP_TAPCELL_ROW_12_116 VGND VPWR sky130_fd_sc_hd__tapvpwrvgnd_1
X_419_ _167_ _186_ _187_ VGND VGND VPWR VPWR _002_ sky130_fd_sc_hd__nor3_1
XFILLER_0_29_35 VGND VGND VPWR VPWR sky130_fd_sc_hd__fill_2
XFILLER_0_28_176 VGND VGND VPWR VPWR sky130_fd_sc_hd__decap_3
XFILLER_0_20_37 VGND VGND VPWR VPWR sky130_fd_sc_hd__fill_1
XFILLER_0_0_69 VGND VGND VPWR VPWR sky130_fd_sc_hd__decap_4
XFILLER_0_19_121 VGND VGND VPWR VPWR sky130_fd_sc_hd__fill_2
XFILLER_0_10_81 VGND VGND VPWR VPWR sky130_fd_sc_hd__decap_3
XFILLER_0_25_113 VGND VGND VPWR VPWR sky130_fd_sc_hd__decap_4
XFILLER_0_16_179 VGND VGND VPWR VPWR sky130_fd_sc_hd__decap_3
XFILLER_0_16_157 VGND VGND VPWR VPWR sky130_fd_sc_hd__fill_1
XFILLER_0_30_193 VGND VGND VPWR VPWR sky130_fd_sc_hd__decap_3
XFILLER_0_13_105 VGND VGND VPWR VPWR sky130_fd_sc_hd__decap_6
X_598_ clknet_3_0__leaf_clk _041_ net46 VGND VGND VPWR VPWR txtop.pCalc.memory\[1\]
+ sky130_fd_sc_hd__dfrtp_1
X_383_ _151_ _149_ _162_ VGND VGND VPWR VPWR _163_ sky130_fd_sc_hd__a21oi_1
XTAP_TAPCELL_ROW_27_166 VGND VPWR sky130_fd_sc_hd__tapvpwrvgnd_1
X_521_ _254_ VGND VGND VPWR VPWR _044_ sky130_fd_sc_hd__clkbuf_1
X_452_ net43 _093_ VGND VGND VPWR VPWR _213_ sky130_fd_sc_hd__and2_1
XFILLER_0_8_121 VGND VGND VPWR VPWR sky130_fd_sc_hd__fill_2
XFILLER_0_12_27 VGND VGND VPWR VPWR sky130_fd_sc_hd__fill_1
XTAP_TAPCELL_ROW_24_158 VGND VPWR sky130_fd_sc_hd__tapvpwrvgnd_1
XFILLER_0_5_146 VGND VGND VPWR VPWR sky130_fd_sc_hd__decap_4
X_366_ _143_ _144_ _145_ VGND VGND VPWR VPWR _146_ sky130_fd_sc_hd__mux2_1
X_504_ _238_ net22 VGND VGND VPWR VPWR _246_ sky130_fd_sc_hd__and2_1
X_297_ txtop.fsm_tx.BAUD_COUNTER\[2\] _083_ VGND VGND VPWR VPWR _086_ sky130_fd_sc_hd__nor2_1
XTAP_TAPCELL_ROW_15_125 VGND VPWR sky130_fd_sc_hd__tapvpwrvgnd_1
X_435_ _199_ VGND VGND VPWR VPWR _013_ sky130_fd_sc_hd__clkbuf_1
XFILLER_0_13_81 VPWR VGND VPWR VGND sky130_ef_sc_hd__decap_12
XFILLER_0_3_69 VGND VGND VPWR VPWR sky130_fd_sc_hd__fill_1
XANTENNA_input1_A div[0] VGND VGND VPWR VPWR sky130_fd_sc_hd__diode_2
X_349_ _127_ _128_ VGND VGND VPWR VPWR _129_ sky130_fd_sc_hd__and2_1
X_418_ BRG.counter\[10\] _183_ net119 VGND VGND VPWR VPWR _187_ sky130_fd_sc_hd__a21oi_1
XFILLER_0_28_133 VGND VGND VPWR VPWR sky130_fd_sc_hd__decap_6
XFILLER_0_20_27 VGND VGND VPWR VPWR sky130_fd_sc_hd__fill_1
XFILLER_0_0_48 VGND VGND VPWR VPWR sky130_fd_sc_hd__fill_2
XFILLER_0_0_15 VGND VGND VPWR VPWR sky130_fd_sc_hd__decap_6
XFILLER_0_19_199 VGND VGND VPWR VPWR sky130_fd_sc_hd__decap_3
XFILLER_0_19_155 VGND VGND VPWR VPWR sky130_fd_sc_hd__fill_1
XFILLER_0_19_133 VGND VGND VPWR VPWR sky130_fd_sc_hd__fill_2
XFILLER_0_9_57 VGND VGND VPWR VPWR sky130_fd_sc_hd__decap_8
XFILLER_0_25_169 VGND VGND VPWR VPWR sky130_fd_sc_hd__fill_2
XFILLER_0_25_158 VGND VGND VPWR VPWR sky130_fd_sc_hd__fill_1
XFILLER_0_25_125 VGND VGND VPWR VPWR sky130_fd_sc_hd__decap_6
XFILLER_0_24_191 VGND VGND VPWR VPWR sky130_fd_sc_hd__decap_4
XFILLER_0_22_139 VGND VGND VPWR VPWR sky130_fd_sc_hd__fill_1
XFILLER_0_26_26 VGND VGND VPWR VPWR sky130_fd_sc_hd__fill_2
X_597_ clknet_3_0__leaf_clk _040_ net46 VGND VGND VPWR VPWR txtop.pCalc.memory\[0\]
+ sky130_fd_sc_hd__dfrtp_1
Xhold60 rxtop.deserializer.ptr\[3\] VGND VGND VPWR VPWR net116 sky130_fd_sc_hd__dlygate4sd3_1
X_520_ net113 net22 _238_ VGND VGND VPWR VPWR _254_ sky130_fd_sc_hd__mux2_1
XFILLER_0_20_6 VGND VGND VPWR VPWR sky130_fd_sc_hd__fill_2
XFILLER_0_12_194 VGND VGND VPWR VPWR sky130_fd_sc_hd__fill_2
X_382_ _127_ _161_ VGND VGND VPWR VPWR _162_ sky130_fd_sc_hd__xnor2_1
XTAP_TAPCELL_ROW_27_167 VGND VPWR sky130_fd_sc_hd__tapvpwrvgnd_1
XTAP_TAPCELL_ROW_18_134 VGND VPWR sky130_fd_sc_hd__tapvpwrvgnd_1
X_451_ net60 _211_ _065_ VGND VGND VPWR VPWR _016_ sky130_fd_sc_hd__o21a_1
XFILLER_0_5_169 VGND VGND VPWR VPWR sky130_fd_sc_hd__fill_2
XFILLER_0_32_201 VGND VGND VPWR VPWR sky130_fd_sc_hd__fill_1
X_365_ BRG.counter\[1\] net4 VGND VGND VPWR VPWR _145_ sky130_fd_sc_hd__xor2_1
X_296_ _083_ _085_ VGND VGND VPWR VPWR txtop.fsm_tx.BAUD_COUNTER_Next\[1\] sky130_fd_sc_hd__nor2_1
XTAP_TAPCELL_ROW_15_126 VGND VPWR sky130_fd_sc_hd__tapvpwrvgnd_1
X_503_ _245_ VGND VGND VPWR VPWR _035_ sky130_fd_sc_hd__clkbuf_1
X_434_ _198_ rxtop.fsm_rx.Current\[1\] _196_ VGND VGND VPWR VPWR _199_ sky130_fd_sc_hd__mux2_1
XFILLER_0_14_201 VGND VGND VPWR VPWR sky130_fd_sc_hd__fill_1
XFILLER_0_13_93 VPWR VGND VPWR VGND sky130_ef_sc_hd__decap_12
XFILLER_0_3_15 VGND VGND VPWR VPWR sky130_fd_sc_hd__decap_6
X_348_ _125_ _126_ net11 VGND VGND VPWR VPWR _128_ sky130_fd_sc_hd__o21ai_1
X_417_ BRG.counter\[11\] BRG.counter\[10\] _183_ VGND VGND VPWR VPWR _186_ sky130_fd_sc_hd__and3_1
XPHY_EDGE_ROW_25_Right_25 VGND VGND VPWR VPWR sky130_fd_sc_hd__decap_3
XFILLER_0_18_27 VGND VGND VPWR VPWR sky130_fd_sc_hd__fill_1
XPHY_EDGE_ROW_16_Right_16 VGND VGND VPWR VPWR sky130_fd_sc_hd__decap_3
X_279_ txtop.fsm_tx.Current\[2\] _070_ VGND VGND VPWR VPWR net40 sky130_fd_sc_hd__xnor2_1
XFILLER_0_29_15 VPWR VGND VPWR VGND sky130_ef_sc_hd__decap_12
XFILLER_0_29_3 VPWR VGND VPWR VGND sky130_ef_sc_hd__decap_12
XFILLER_0_28_167 VGND VGND VPWR VPWR sky130_fd_sc_hd__fill_2
XFILLER_0_28_101 VGND VGND VPWR VPWR sky130_fd_sc_hd__fill_2
XFILLER_0_3_201 VGND VGND VPWR VPWR sky130_fd_sc_hd__fill_1
Xclkbuf_3_0__f_clk clknet_0_clk VGND VGND VPWR VPWR clknet_3_0__leaf_clk sky130_fd_sc_hd__clkbuf_16
XFILLER_0_33_181 VPWR VGND VPWR VGND sky130_ef_sc_hd__decap_12
XPHY_EDGE_ROW_2_Right_2 VGND VGND VPWR VPWR sky130_fd_sc_hd__decap_3
XFILLER_0_26_49 VGND VGND VPWR VPWR sky130_fd_sc_hd__fill_1
XFILLER_0_26_16 VGND VGND VPWR VPWR sky130_fd_sc_hd__fill_1
X_596_ clknet_3_3__leaf_clk _039_ net46 VGND VGND VPWR VPWR txtop.serializer.memory\[7\]
+ sky130_fd_sc_hd__dfrtp_1
Xhold61 txtop.pCalc.memory\[3\] VGND VGND VPWR VPWR net117 sky130_fd_sc_hd__dlygate4sd3_1
Xhold50 txtop.serializer.memory\[2\] VGND VGND VPWR VPWR net106 sky130_fd_sc_hd__dlygate4sd3_1
XFILLER_0_6_15 VGND VGND VPWR VPWR sky130_fd_sc_hd__decap_4
XFILLER_0_6_48 VGND VGND VPWR VPWR sky130_fd_sc_hd__decap_6
XFILLER_0_8_145 VGND VGND VPWR VPWR sky130_fd_sc_hd__decap_3
XFILLER_0_8_178 VGND VGND VPWR VPWR sky130_fd_sc_hd__fill_2
X_381_ BRG.counter\[9\] net12 VGND VGND VPWR VPWR _161_ sky130_fd_sc_hd__xor2_1
XTAP_TAPCELL_ROW_27_168 VGND VPWR sky130_fd_sc_hd__tapvpwrvgnd_1
X_450_ _210_ _212_ net65 _211_ VGND VGND VPWR VPWR _015_ sky130_fd_sc_hd__o2bb2a_1
XFILLER_0_12_29 VGND VGND VPWR VPWR sky130_fd_sc_hd__fill_1
Xoutput40 net40 VGND VGND VPWR VPWR tx_busy sky130_fd_sc_hd__buf_2
X_579_ clknet_3_3__leaf_clk _009_ net48 VGND VGND VPWR VPWR BRG.counter\[7\] sky130_fd_sc_hd__dfrtp_2
XTAP_TAPCELL_ROW_18_135 VGND VPWR sky130_fd_sc_hd__tapvpwrvgnd_1
XFILLER_0_23_17 VGND VGND VPWR VPWR sky130_fd_sc_hd__decap_4
X_502_ _244_ net107 _235_ VGND VGND VPWR VPWR _245_ sky130_fd_sc_hd__mux2_1
X_433_ net13 _069_ _093_ _193_ VGND VGND VPWR VPWR _198_ sky130_fd_sc_hd__a211o_1
XTAP_TAPCELL_ROW_9_103 VGND VPWR sky130_fd_sc_hd__tapvpwrvgnd_1
X_364_ net1 BRG.counter\[0\] VGND VGND VPWR VPWR _144_ sky130_fd_sc_hd__or2b_1
X_295_ net90 _082_ _084_ VGND VGND VPWR VPWR _085_ sky130_fd_sc_hd__o21ai_1
XFILLER_0_1_195 VGND VGND VPWR VPWR sky130_fd_sc_hd__fill_2
X_347_ net11 _125_ _126_ VGND VGND VPWR VPWR _127_ sky130_fd_sc_hd__or3_1
X_416_ _168_ _185_ VGND VGND VPWR VPWR _001_ sky130_fd_sc_hd__nor2_1
XPHY_EDGE_ROW_25_Left_59 VGND VGND VPWR VPWR sky130_fd_sc_hd__decap_3
XTAP_TAPCELL_ROW_20_141 VGND VPWR sky130_fd_sc_hd__tapvpwrvgnd_1
X_278_ txtop.fsm_tx.Current\[1\] txtop.fsm_tx.Current\[0\] VGND VGND VPWR VPWR _070_
+ sky130_fd_sc_hd__nor2_1
XFILLER_0_0_3 VPWR VGND VPWR VGND sky130_ef_sc_hd__decap_12
XFILLER_0_29_27 VGND VGND VPWR VPWR sky130_fd_sc_hd__decap_8
XFILLER_0_20_29 VGND VGND VPWR VPWR sky130_fd_sc_hd__decap_8
XFILLER_0_10_73 VGND VGND VPWR VPWR sky130_fd_sc_hd__decap_8
XFILLER_0_19_113 VGND VGND VPWR VPWR sky130_fd_sc_hd__decap_8
XFILLER_0_33_193 VGND VGND VPWR VPWR sky130_fd_sc_hd__decap_3
XPHY_EDGE_ROW_28_Left_62 VGND VGND VPWR VPWR sky130_fd_sc_hd__decap_3
XFILLER_0_25_105 VGND VGND VPWR VPWR sky130_fd_sc_hd__decap_6
XFILLER_0_21_50 VGND VGND VPWR VPWR sky130_fd_sc_hd__decap_6
XFILLER_0_16_138 VGND VGND VPWR VPWR sky130_fd_sc_hd__fill_2
XPHY_EDGE_ROW_12_Left_46 VGND VGND VPWR VPWR sky130_fd_sc_hd__decap_3
XFILLER_0_30_141 VPWR VGND VPWR VGND sky130_ef_sc_hd__decap_12
XFILLER_0_22_108 VGND VGND VPWR VPWR sky130_fd_sc_hd__decap_6
XANTENNA_input25_A tx_in[7] VGND VGND VPWR VPWR sky130_fd_sc_hd__diode_2
Xhold62 txtop.pCalc.memory\[5\] VGND VGND VPWR VPWR net118 sky130_fd_sc_hd__dlygate4sd3_1
Xhold40 net38 VGND VGND VPWR VPWR net96 sky130_fd_sc_hd__dlygate4sd3_1
X_595_ clknet_3_1__leaf_clk net59 net46 VGND VGND VPWR VPWR txtop.serializer.memory\[6\]
+ sky130_fd_sc_hd__dfrtp_1
Xhold51 txtop.serializer.memory\[3\] VGND VGND VPWR VPWR net107 sky130_fd_sc_hd__dlygate4sd3_1
XFILLER_0_16_83 VGND VGND VPWR VPWR sky130_fd_sc_hd__fill_1
XFILLER_0_13_7 VPWR VGND VPWR VGND sky130_ef_sc_hd__decap_12
XFILLER_0_6_27 VGND VGND VPWR VPWR sky130_fd_sc_hd__fill_1
X_380_ BRG.counter\[8\] _129_ _149_ _151_ _159_ VGND VGND VPWR VPWR _160_ sky130_fd_sc_hd__o221a_1
XFILLER_0_12_141 VGND VGND VPWR VPWR sky130_fd_sc_hd__decap_4
XTAP_TAPCELL_ROW_2_78 VGND VPWR sky130_fd_sc_hd__tapvpwrvgnd_1
Xoutput41 net41 VGND VGND VPWR VPWR tx_done sky130_fd_sc_hd__buf_2
Xoutput30 net30 VGND VGND VPWR VPWR rx_done sky130_fd_sc_hd__buf_2
X_578_ clknet_3_2__leaf_clk _008_ net48 VGND VGND VPWR VPWR BRG.counter\[6\] sky130_fd_sc_hd__dfrtp_1
XTAP_TAPCELL_ROW_18_136 VGND VPWR sky130_fd_sc_hd__tapvpwrvgnd_1
.ends
